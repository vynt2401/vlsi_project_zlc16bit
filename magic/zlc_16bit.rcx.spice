* NGSPICE file created from zlc_16bit.ext - technology: sky130A

.subckt zlc_16bit Y[4] Y[3] Y[2] Y[1] Y[0] A[15] A[12] A[13] A[14] A[11] A[8] A[9]
+ A[10] A[6] A[5] A[4] A[7] A[2] A[1] A[0] A[3] VDD GND
X0 VDD.t94 a_1143_n2463# a_1173_n2110# VDD.t93 sky130_fd_pr__pfet_01v8_hvt ad=0.0693 pd=0.75 as=0.0441 ps=0.63 w=0.42 l=0.15
X1 a_2370_n2285# x13.A0 a_2512_n2110# VDD.t39 sky130_fd_pr__pfet_01v8_hvt ad=0.1932 pd=1.34 as=0.07665 ps=0.785 w=0.42 l=0.15
X2 x4.x8.X a_2830_n4755# GND.t109 GND.t108 sky130_fd_pr__nfet_01v8 ad=0.169 pd=1.82 as=0.10025 ps=0.985 w=0.65 l=0.15
X3 a_2580_n477# x11.B a_2498_n477# VDD.t110 sky130_fd_pr__pfet_01v8_hvt ad=0.0441 pd=0.63 as=0.1092 ps=1.36 w=0.42 l=0.15
X4 a_898_n1355# A[8].t2 GND.t166 GND.t165 sky130_fd_pr__nfet_01v8 ad=0.0567 pd=0.69 as=0.1092 ps=1.36 w=0.42 l=0.15
X5 a_856_n2110# Y[3].t9 VDD.t202 VDD.t201 sky130_fd_pr__pfet_01v8_hvt ad=0.07665 pd=0.785 as=0.15835 ps=1.395 w=0.42 l=0.15
X6 a_1139_n727# x2.Z[2] a_1067_n727# GND.t62 sky130_fd_pr__nfet_01v8 ad=0.0441 pd=0.63 as=0.0441 ps=0.63 w=0.42 l=0.15
X7 GND.t36 x4.Z[2] x9.Y GND.t35 sky130_fd_pr__nfet_01v8 ad=0.169 pd=1.82 as=0.169 ps=1.82 w=0.65 l=0.15
X8 a_714_n2285# x13.X a_856_n2110# VDD.t95 sky130_fd_pr__pfet_01v8_hvt ad=0.1932 pd=1.34 as=0.07665 ps=0.785 w=0.42 l=0.15
X9 VDD.t253 A[0].t1 a_2361_n4977# VDD.t252 sky130_fd_pr__pfet_01v8_hvt ad=0.16655 pd=1.39 as=0.0567 ps=0.69 w=0.42 l=0.15
X10 VDD.t174 A[9].t4 a_980_n1355# VDD.t173 sky130_fd_pr__pfet_01v8_hvt ad=0.14575 pd=1.335 as=0.0441 ps=0.63 w=0.42 l=0.15
X11 VDD.t104 a_1971_n2463# a_2001_n2110# VDD.t103 sky130_fd_pr__pfet_01v8_hvt ad=0.0693 pd=0.75 as=0.0441 ps=0.63 w=0.42 l=0.15
X12 a_980_n3055# A[4].t4 a_898_n3055# VDD.t213 sky130_fd_pr__pfet_01v8_hvt ad=0.0441 pd=0.63 as=0.1092 ps=1.36 w=0.42 l=0.15
X13 x4.Z[1] a_1349_n4977# VDD.t169 VDD.t168 sky130_fd_pr__pfet_01v8_hvt ad=0.475 pd=2.95 as=0.16655 ps=1.39 w=1 l=0.15
X14 GND.t29 x1.x7.X a_2830_345# GND.t28 sky130_fd_pr__nfet_01v8 ad=0.10025 pd=0.985 as=0.0567 ps=0.69 w=0.42 l=0.15
X15 a_663_n1355# A[10].t4 x2.x2.Y VDD.t248 sky130_fd_pr__pfet_01v8_hvt ad=0.105 pd=1.21 as=0.26 ps=2.52 w=1 l=0.15
X16 a_391_n3055# A[6].t5 a_285_n3055# VDD.t227 sky130_fd_pr__pfet_01v8_hvt ad=0.135 pd=1.27 as=0.19 ps=1.38 w=1 l=0.15
X17 VDD.t231 A[3].t5 a_391_n4755# VDD.t230 sky130_fd_pr__pfet_01v8_hvt ad=0.26 pd=2.52 as=0.135 ps=1.27 w=1 l=0.15
X18 x17.A0 a_3281_n3277# GND.t3 GND.t2 sky130_fd_pr__nfet_01v8 ad=0.182 pd=1.86 as=0.1118 ps=1.04 w=0.65 l=0.15
X19 x16.A0 a_3281_123# GND.t25 GND.t24 sky130_fd_pr__nfet_01v8 ad=0.182 pd=1.86 as=0.1118 ps=1.04 w=0.65 l=0.15
X20 a_391_345# A[14].t5 a_285_345# VDD.t209 sky130_fd_pr__pfet_01v8_hvt ad=0.135 pd=1.27 as=0.19 ps=1.38 w=1 l=0.15
X21 GND.t241 A[15].t3 x5.A GND.t240 sky130_fd_pr__nfet_01v8 ad=0.169 pd=1.82 as=0.08775 ps=0.92 w=0.65 l=0.15
X22 a_1349_123# x1.x2.Y VDD.t22 VDD.t21 sky130_fd_pr__pfet_01v8_hvt ad=0.0567 pd=0.69 as=0.1176 ps=1.4 w=0.42 l=0.15
X23 GND.t140 A[13].t3 x5.A GND.t139 sky130_fd_pr__nfet_01v8 ad=0.08937 pd=0.925 as=0.11863 ps=1.015 w=0.65 l=0.15
X24 VDD.t217 A[11].t4 a_663_n1355# VDD.t216 sky130_fd_pr__pfet_01v8_hvt ad=0.26 pd=2.52 as=0.105 ps=1.21 w=1 l=0.15
X25 a_2361_n4977# x4.x6.Y VDD.t182 VDD.t181 sky130_fd_pr__pfet_01v8_hvt ad=0.0567 pd=0.69 as=0.1176 ps=1.4 w=0.42 l=0.15
X26 a_2912_345# A[14].t1 a_2830_345# VDD.t211 sky130_fd_pr__pfet_01v8_hvt ad=0.0441 pd=0.63 as=0.1092 ps=1.36 w=0.42 l=0.15
X27 GND.t46 x1.x8.X a_3367_123# GND.t45 sky130_fd_pr__nfet_01v8 ad=0.1118 pd=1.04 as=0.0567 ps=0.69 w=0.42 l=0.15
X28 x2.x3.X a_898_n1355# VDD.t78 VDD.t77 sky130_fd_pr__pfet_01v8_hvt ad=0.34 pd=2.68 as=0.14575 ps=1.335 w=1 l=0.15
X29 a_1349_n3277# x3.x2.Y VDD.t160 VDD.t159 sky130_fd_pr__pfet_01v8_hvt ad=0.0567 pd=0.69 as=0.1176 ps=1.4 w=0.42 l=0.15
X30 x3.x6.Y A[5].t1 VDD.t224 VDD.t223 sky130_fd_pr__pfet_01v8_hvt ad=0.26 pd=2.52 as=0.26 ps=2.52 w=1 l=0.15
X31 x1.x5.Y A[15].t0 GND.t243 GND.t242 sky130_fd_pr__nfet_01v8 ad=0.169 pd=1.82 as=0.169 ps=1.82 w=0.65 l=0.15
X32 VDD.t43 x4.Z[2] a_65_n727# VDD.t42 sky130_fd_pr__pfet_01v8_hvt ad=0.31245 pd=1.68 as=0.0588 ps=0.7 w=0.42 l=0.15
X33 x4.Z[0] a_3281_n4977# VDD.t122 VDD.t121 sky130_fd_pr__pfet_01v8_hvt ad=0.475 pd=2.95 as=0.16655 ps=1.39 w=1 l=0.15
X34 a_1684_n4137# Y[2].t5 GND.t179 GND.t178 sky130_fd_pr__nfet_01v8 ad=0.0693 pd=0.75 as=0.11285 ps=1.045 w=0.42 l=0.15
X35 GND.t187 a_1143_n4163# a_1077_n4137# GND.t186 sky130_fd_pr__nfet_01v8 ad=0.1449 pd=1.11 as=0.0693 ps=0.75 w=0.42 l=0.15
X36 x11.B a_2029_n699# GND.t56 GND.t55 sky130_fd_pr__nfet_01v8 ad=0.182 pd=1.86 as=0.1118 ps=1.04 w=0.65 l=0.15
X37 VDD.t28 x5.A a_985_n727# VDD.t27 sky130_fd_pr__pfet_01v8_hvt ad=0.0567 pd=0.69 as=0.1092 ps=1.36 w=0.42 l=0.15
X38 a_1143_n2463# Y[3].t8 VDD.t204 VDD.t203 sky130_fd_pr__pfet_01v8_hvt ad=0.1176 pd=1.4 as=0.0693 ps=0.75 w=0.42 l=0.15
X39 a_2001_n2110# x4.Z[1] a_1542_n2285# VDD.t105 sky130_fd_pr__pfet_01v8_hvt ad=0.0441 pd=0.63 as=0.1932 ps=1.34 w=0.42 l=0.15
X40 VDD.t244 A[15].t4 a_663_345# VDD.t243 sky130_fd_pr__pfet_01v8_hvt ad=0.26 pd=2.52 as=0.105 ps=1.21 w=1 l=0.15
X41 a_2830_n4755# A[2].t0 GND.t267 GND.t266 sky130_fd_pr__nfet_01v8 ad=0.0567 pd=0.69 as=0.1092 ps=1.36 w=0.42 l=0.15
X42 GND.t209 A[11].t3 x2.Z[2] GND.t208 sky130_fd_pr__nfet_01v8 ad=0.169 pd=1.82 as=0.08775 ps=0.92 w=0.65 l=0.15
X43 x13.A1 a_1349_n1577# GND.t144 GND.t143 sky130_fd_pr__nfet_01v8 ad=0.182 pd=1.86 as=0.1118 ps=1.04 w=0.65 l=0.15
X44 x3.Z[2] A[4].t3 GND.t205 GND.t204 sky130_fd_pr__nfet_01v8 ad=0.11863 pd=1.015 as=0.169 ps=1.82 w=0.65 l=0.15
X45 a_2512_n4137# Y[2].t3 GND.t177 GND.t176 sky130_fd_pr__nfet_01v8 ad=0.0693 pd=0.75 as=0.11285 ps=1.045 w=0.42 l=0.15
X46 a_1077_n2437# x13.X a_714_n2285# GND.t80 sky130_fd_pr__nfet_01v8 ad=0.0693 pd=0.75 as=0.09975 ps=0.895 w=0.42 l=0.15
X47 GND.t215 A[5].t3 x3.Z[2] GND.t214 sky130_fd_pr__nfet_01v8 ad=0.08937 pd=0.925 as=0.11863 ps=1.015 w=0.65 l=0.15
X48 a_1905_n4137# x17.A0 a_1542_n3985# GND.t10 sky130_fd_pr__nfet_01v8 ad=0.0693 pd=0.75 as=0.09975 ps=0.895 w=0.42 l=0.15
X49 GND.t102 a_1542_n3985# x17.X GND.t101 sky130_fd_pr__nfet_01v8 ad=0.11285 pd=1.045 as=0.169 ps=1.82 w=0.65 l=0.15
X50 VDD.t81 x2.x3.X a_1349_n1577# VDD.t80 sky130_fd_pr__pfet_01v8_hvt ad=0.16655 pd=1.39 as=0.0567 ps=0.69 w=0.42 l=0.15
X51 x4.x5.Y A[3].t0 GND.t229 GND.t228 sky130_fd_pr__nfet_01v8 ad=0.169 pd=1.82 as=0.169 ps=1.82 w=0.65 l=0.15
X52 a_856_n4137# Y[3].t3 GND.t193 GND.t192 sky130_fd_pr__nfet_01v8 ad=0.0693 pd=0.75 as=0.11285 ps=1.045 w=0.42 l=0.15
X53 x1.x8.X a_2830_345# GND.t27 GND.t26 sky130_fd_pr__nfet_01v8 ad=0.169 pd=1.82 as=0.10025 ps=0.985 w=0.65 l=0.15
X54 a_2949_n699# x5.A VDD.t26 VDD.t25 sky130_fd_pr__pfet_01v8_hvt ad=0.0567 pd=0.69 as=0.1176 ps=1.4 w=0.42 l=0.15
X55 GND.t136 a_2370_n3985# x16.X GND.t135 sky130_fd_pr__nfet_01v8 ad=0.11285 pd=1.045 as=0.169 ps=1.82 w=0.65 l=0.15
X56 x3.x8.X a_2830_n3055# GND.t147 GND.t146 sky130_fd_pr__nfet_01v8 ad=0.169 pd=1.82 as=0.10025 ps=0.985 w=0.65 l=0.15
X57 VDD.t70 x8.Y a_2580_n477# VDD.t69 sky130_fd_pr__pfet_01v8_hvt ad=0.14575 pd=1.335 as=0.0441 ps=0.63 w=0.42 l=0.15
X58 GND.t128 x4.x8.X a_3367_n4977# GND.t127 sky130_fd_pr__nfet_01v8 ad=0.1118 pd=1.04 as=0.0567 ps=0.69 w=0.42 l=0.15
X59 x10.B a_2498_n477# GND.t54 GND.t53 sky130_fd_pr__nfet_01v8 ad=0.169 pd=1.82 as=0.10025 ps=0.985 w=0.65 l=0.15
X60 VDD.t107 a_2799_n2463# a_2829_n2110# VDD.t106 sky130_fd_pr__pfet_01v8_hvt ad=0.0693 pd=0.75 as=0.0441 ps=0.63 w=0.42 l=0.15
X61 a_285_n3055# A[5].t5 a_203_n3055# VDD.t222 sky130_fd_pr__pfet_01v8_hvt ad=0.19 pd=1.38 as=0.13 ps=1.26 w=1 l=0.15
X62 VDD.t215 A[4].t1 a_2361_n3277# VDD.t214 sky130_fd_pr__pfet_01v8_hvt ad=0.16655 pd=1.39 as=0.0567 ps=0.69 w=0.42 l=0.15
X63 GND.t138 A[13].t2 a_898_345# GND.t137 sky130_fd_pr__nfet_01v8 ad=0.10025 pd=0.985 as=0.0567 ps=0.69 w=0.42 l=0.15
X64 VDD.t68 x9.Y a_2029_n699# VDD.t67 sky130_fd_pr__pfet_01v8_hvt ad=0.16655 pd=1.39 as=0.0567 ps=0.69 w=0.42 l=0.15
X65 a_391_n1355# A[10].t5 a_285_n1355# VDD.t247 sky130_fd_pr__pfet_01v8_hvt ad=0.135 pd=1.27 as=0.19 ps=1.38 w=1 l=0.15
X66 a_980_n1355# A[8].t4 a_898_n1355# VDD.t178 sky130_fd_pr__pfet_01v8_hvt ad=0.0441 pd=0.63 as=0.1092 ps=1.36 w=0.42 l=0.15
X67 x16.A1 a_3281_n1577# GND.t8 GND.t7 sky130_fd_pr__nfet_01v8 ad=0.182 pd=1.86 as=0.1118 ps=1.04 w=0.65 l=0.15
X68 a_203_n4755# A[0].t5 x4.Z[2] VDD.t250 sky130_fd_pr__pfet_01v8_hvt ad=0.13 pd=1.26 as=0.26 ps=2.52 w=1 l=0.15
X69 GND.t149 a_714_n3985# Y[0].t1 GND.t148 sky130_fd_pr__nfet_01v8 ad=0.11285 pd=1.045 as=0.169 ps=1.82 w=0.65 l=0.15
X70 a_2829_n3810# x16.A1 a_2370_n3985# VDD.t86 sky130_fd_pr__pfet_01v8_hvt ad=0.0441 pd=0.63 as=0.1932 ps=1.34 w=0.42 l=0.15
X71 a_3367_123# x1.x5.Y a_3281_123# GND.t31 sky130_fd_pr__nfet_01v8 ad=0.0567 pd=0.69 as=0.1176 ps=1.4 w=0.42 l=0.15
X72 a_1971_n4163# Y[2].t8 VDD.t196 VDD.t195 sky130_fd_pr__pfet_01v8_hvt ad=0.1176 pd=1.4 as=0.0693 ps=0.75 w=0.42 l=0.15
X73 Y[4].t1 a_65_n727# VDD.t58 VDD.t57 sky130_fd_pr__pfet_01v8_hvt ad=0.26 pd=2.52 as=0.31245 ps=1.68 w=1 l=0.15
X74 a_1542_n3985# x4.Z[0] a_1684_n4137# GND.t150 sky130_fd_pr__nfet_01v8 ad=0.09975 pd=0.895 as=0.0693 ps=0.75 w=0.42 l=0.15
X75 x4.x8.X a_2830_n4755# VDD.t124 VDD.t123 sky130_fd_pr__pfet_01v8_hvt ad=0.34 pd=2.68 as=0.14575 ps=1.335 w=1 l=0.15
X76 a_3367_n4977# x4.x5.Y a_3281_n4977# GND.t103 sky130_fd_pr__nfet_01v8 ad=0.0567 pd=0.69 as=0.1176 ps=1.4 w=0.42 l=0.15
X77 x1.x5.Y A[15].t1 VDD.t246 VDD.t245 sky130_fd_pr__pfet_01v8_hvt ad=0.26 pd=2.52 as=0.26 ps=2.52 w=1 l=0.15
X78 a_2361_n3277# x3.x6.Y VDD.t146 VDD.t145 sky130_fd_pr__pfet_01v8_hvt ad=0.0567 pd=0.69 as=0.1176 ps=1.4 w=0.42 l=0.15
X79 x2.x6.Y A[9].t1 VDD.t176 VDD.t175 sky130_fd_pr__pfet_01v8_hvt ad=0.26 pd=2.52 as=0.26 ps=2.52 w=1 l=0.15
X80 VDD.t257 A[7].t5 a_391_n3055# VDD.t256 sky130_fd_pr__pfet_01v8_hvt ad=0.26 pd=2.52 as=0.135 ps=1.27 w=1 l=0.15
X81 x3.Z[1] a_1349_n3277# VDD.t112 VDD.t111 sky130_fd_pr__pfet_01v8_hvt ad=0.475 pd=2.95 as=0.16655 ps=1.39 w=1 l=0.15
X82 GND.t152 a_1971_n4163# a_1905_n4137# GND.t151 sky130_fd_pr__nfet_01v8 ad=0.1449 pd=1.11 as=0.0693 ps=0.75 w=0.42 l=0.15
X83 GND.t79 a_1143_n2463# a_1077_n2437# GND.t78 sky130_fd_pr__nfet_01v8 ad=0.1449 pd=1.11 as=0.0693 ps=0.75 w=0.42 l=0.15
X84 a_1684_n2437# Y[2].t13 GND.t181 GND.t180 sky130_fd_pr__nfet_01v8 ad=0.0693 pd=0.75 as=0.11285 ps=1.045 w=0.42 l=0.15
X85 a_1143_n4163# Y[3].t2 GND.t195 GND.t194 sky130_fd_pr__nfet_01v8 ad=0.1092 pd=1.36 as=0.1449 ps=1.11 w=0.42 l=0.15
X86 a_795_n727# x4.Z[2] GND.t38 GND.t37 sky130_fd_pr__nfet_01v8 ad=0.08775 pd=0.92 as=0.169 ps=1.82 w=0.65 l=0.15
X87 a_714_n3985# x17.X a_856_n4137# GND.t134 sky130_fd_pr__nfet_01v8 ad=0.09975 pd=0.895 as=0.0693 ps=0.75 w=0.42 l=0.15
X88 VDD.t156 A[13].t4 a_980_345# VDD.t155 sky130_fd_pr__pfet_01v8_hvt ad=0.14575 pd=1.335 as=0.0441 ps=0.63 w=0.42 l=0.15
X89 a_235_n727# x2.Z[2] a_147_n727# GND.t61 sky130_fd_pr__nfet_01v8 ad=0.0798 pd=0.8 as=0.0609 ps=0.71 w=0.42 l=0.15
X90 GND.t40 x4.Z[2] a_341_n727# GND.t39 sky130_fd_pr__nfet_01v8 ad=0.19627 pd=1.33 as=0.0693 ps=0.75 w=0.42 l=0.15
X91 x2.Z[2] A[8].t3 GND.t164 GND.t163 sky130_fd_pr__nfet_01v8 ad=0.11863 pd=1.015 as=0.169 ps=1.82 w=0.65 l=0.15
X92 a_2830_n3055# A[6].t0 GND.t225 GND.t224 sky130_fd_pr__nfet_01v8 ad=0.0567 pd=0.69 as=0.1092 ps=1.36 w=0.42 l=0.15
X93 a_65_n727# x3.Z[2] VDD.t49 VDD.t48 sky130_fd_pr__pfet_01v8_hvt ad=0.0588 pd=0.7 as=0.0777 ps=0.79 w=0.42 l=0.15
X94 GND.t85 a_1542_n2285# x14.X GND.t84 sky130_fd_pr__nfet_01v8 ad=0.11285 pd=1.045 as=0.169 ps=1.82 w=0.65 l=0.15
X95 a_1905_n2437# x3.Z[1] a_1542_n2285# GND.t13 sky130_fd_pr__nfet_01v8 ad=0.0693 pd=0.75 as=0.09975 ps=0.895 w=0.42 l=0.15
X96 a_2512_n2437# Y[2].t11 GND.t175 GND.t174 sky130_fd_pr__nfet_01v8 ad=0.0693 pd=0.75 as=0.11285 ps=1.045 w=0.42 l=0.15
X97 VDD.t72 x2.Z[2] a_65_n727# VDD.t71 sky130_fd_pr__pfet_01v8_hvt ad=0.0777 pd=0.79 as=0.0735 ps=0.77 w=0.42 l=0.15
X98 VDD.t47 x4.Z[2] x9.Y VDD.t46 sky130_fd_pr__pfet_01v8_hvt ad=0.26 pd=2.52 as=0.26 ps=2.52 w=1 l=0.15
X99 a_1349_n1577# x2.x2.Y VDD.t83 VDD.t82 sky130_fd_pr__pfet_01v8_hvt ad=0.0567 pd=0.69 as=0.1176 ps=1.4 w=0.42 l=0.15
X100 GND.t158 A[9].t3 x2.Z[2] GND.t157 sky130_fd_pr__nfet_01v8 ad=0.08937 pd=0.925 as=0.11863 ps=1.015 w=0.65 l=0.15
X101 a_663_345# A[14].t4 x1.x2.Y VDD.t210 sky130_fd_pr__pfet_01v8_hvt ad=0.105 pd=1.21 as=0.26 ps=2.52 w=1 l=0.15
X102 a_856_n2437# Y[3].t7 GND.t189 GND.t188 sky130_fd_pr__nfet_01v8 ad=0.0693 pd=0.75 as=0.11285 ps=1.045 w=0.42 l=0.15
X103 x3.x5.Y A[7].t0 GND.t257 GND.t256 sky130_fd_pr__nfet_01v8 ad=0.169 pd=1.82 as=0.169 ps=1.82 w=0.65 l=0.15
X104 x17.A0 a_3281_n3277# VDD.t3 VDD.t2 sky130_fd_pr__pfet_01v8_hvt ad=0.475 pd=2.95 as=0.16655 ps=1.39 w=1 l=0.15
X105 x2.x8.X a_2830_n1355# GND.t1 GND.t0 sky130_fd_pr__nfet_01v8 ad=0.169 pd=1.82 as=0.10025 ps=0.985 w=0.65 l=0.15
X106 GND.t83 a_2370_n2285# x13.X GND.t82 sky130_fd_pr__nfet_01v8 ad=0.11285 pd=1.045 as=0.169 ps=1.82 w=0.65 l=0.15
X107 x4.x7.X a_2361_n4977# GND.t111 GND.t110 sky130_fd_pr__nfet_01v8 ad=0.182 pd=1.86 as=0.1118 ps=1.04 w=0.65 l=0.15
X108 GND.t116 x4.x7.X a_2830_n4755# GND.t115 sky130_fd_pr__nfet_01v8 ad=0.10025 pd=0.985 as=0.0567 ps=0.69 w=0.42 l=0.15
X109 a_2498_n477# x11.B GND.t96 GND.t95 sky130_fd_pr__nfet_01v8 ad=0.0567 pd=0.69 as=0.1092 ps=1.36 w=0.42 l=0.15
X110 a_285_n1355# A[9].t5 a_203_n1355# VDD.t172 sky130_fd_pr__pfet_01v8_hvt ad=0.19 pd=1.38 as=0.13 ps=1.26 w=1 l=0.15
X111 GND.t87 a_714_n2285# Y[1].t0 GND.t86 sky130_fd_pr__nfet_01v8 ad=0.11285 pd=1.045 as=0.169 ps=1.82 w=0.65 l=0.15
X112 a_285_345# A[13].t5 a_203_345# VDD.t152 sky130_fd_pr__pfet_01v8_hvt ad=0.19 pd=1.38 as=0.13 ps=1.26 w=1 l=0.15
X113 a_2799_n4163# Y[2].t6 VDD.t198 VDD.t197 sky130_fd_pr__pfet_01v8_hvt ad=0.1176 pd=1.4 as=0.0693 ps=0.75 w=0.42 l=0.15
X114 VDD.t116 a_1542_n3985# x17.X VDD.t115 sky130_fd_pr__pfet_01v8_hvt ad=0.15835 pd=1.395 as=0.26 ps=2.52 w=1 l=0.15
X115 a_980_345# A[12].t4 a_898_345# VDD.t134 sky130_fd_pr__pfet_01v8_hvt ad=0.0441 pd=0.63 as=0.1092 ps=1.36 w=0.42 l=0.15
X116 x4.x5.Y A[3].t1 VDD.t235 VDD.t234 sky130_fd_pr__pfet_01v8_hvt ad=0.26 pd=2.52 as=0.26 ps=2.52 w=1 l=0.15
X117 a_1542_n2285# x4.Z[1] a_1684_n2437# GND.t90 sky130_fd_pr__nfet_01v8 ad=0.09975 pd=0.895 as=0.0693 ps=0.75 w=0.42 l=0.15
X118 x11.B a_2029_n699# VDD.t66 VDD.t65 sky130_fd_pr__pfet_01v8_hvt ad=0.475 pd=2.95 as=0.16655 ps=1.39 w=1 l=0.15
X119 GND.t113 x4.x3.X a_1435_n4977# GND.t112 sky130_fd_pr__nfet_01v8 ad=0.1118 pd=1.04 as=0.0567 ps=0.69 w=0.42 l=0.15
X120 VDD.t151 a_2370_n3985# x16.X VDD.t150 sky130_fd_pr__pfet_01v8_hvt ad=0.15835 pd=1.395 as=0.26 ps=2.52 w=1 l=0.15
X121 GND.t133 x3.x8.X a_3367_n3277# GND.t132 sky130_fd_pr__nfet_01v8 ad=0.1118 pd=1.04 as=0.0567 ps=0.69 w=0.42 l=0.15
X122 VDD.t56 x1.x8.X a_3281_123# VDD.t55 sky130_fd_pr__pfet_01v8_hvt ad=0.16655 pd=1.39 as=0.0567 ps=0.69 w=0.42 l=0.15
X123 VDD.t180 A[8].t1 a_2361_n1577# VDD.t179 sky130_fd_pr__pfet_01v8_hvt ad=0.16655 pd=1.39 as=0.0567 ps=0.69 w=0.42 l=0.15
X124 x13.A1 a_1349_n1577# VDD.t158 VDD.t157 sky130_fd_pr__pfet_01v8_hvt ad=0.475 pd=2.95 as=0.16655 ps=1.39 w=1 l=0.15
X125 a_203_n3055# A[4].t5 x3.Z[2] VDD.t212 sky130_fd_pr__pfet_01v8_hvt ad=0.13 pd=1.26 as=0.26 ps=2.52 w=1 l=0.15
X126 VDD.t219 A[11].t5 a_391_n1355# VDD.t218 sky130_fd_pr__pfet_01v8_hvt ad=0.26 pd=2.52 as=0.135 ps=1.27 w=1 l=0.15
X127 a_1143_n2463# Y[3].t6 GND.t191 GND.t190 sky130_fd_pr__nfet_01v8 ad=0.1092 pd=1.36 as=0.1449 ps=1.11 w=0.42 l=0.15
X128 GND.t89 a_1971_n2463# a_1905_n2437# GND.t88 sky130_fd_pr__nfet_01v8 ad=0.1449 pd=1.11 as=0.0693 ps=0.75 w=0.42 l=0.15
X129 VDD.t164 a_714_n3985# Y[0].t0 VDD.t163 sky130_fd_pr__pfet_01v8_hvt ad=0.15835 pd=1.395 as=0.26 ps=2.52 w=1 l=0.15
X130 a_1971_n2463# Y[2].t16 VDD.t184 VDD.t183 sky130_fd_pr__pfet_01v8_hvt ad=0.1176 pd=1.4 as=0.0693 ps=0.75 w=0.42 l=0.15
X131 a_2829_n2110# x13.A1 a_2370_n2285# VDD.t79 sky130_fd_pr__pfet_01v8_hvt ad=0.0441 pd=0.63 as=0.1932 ps=1.34 w=0.42 l=0.15
X132 a_714_n2285# x14.X a_856_n2437# GND.t81 sky130_fd_pr__nfet_01v8 ad=0.09975 pd=0.895 as=0.0693 ps=0.75 w=0.42 l=0.15
X133 x8.Y x2.Z[2] GND.t64 GND.t63 sky130_fd_pr__nfet_01v8 ad=0.169 pd=1.82 as=0.169 ps=1.82 w=0.65 l=0.15
X134 a_2830_n1355# A[10].t0 GND.t245 GND.t244 sky130_fd_pr__nfet_01v8 ad=0.0567 pd=0.69 as=0.1092 ps=1.36 w=0.42 l=0.15
X135 x3.x8.X a_2830_n3055# VDD.t162 VDD.t161 sky130_fd_pr__pfet_01v8_hvt ad=0.34 pd=2.68 as=0.14575 ps=1.335 w=1 l=0.15
X136 a_3367_n3277# x3.x5.Y a_3281_n3277# GND.t9 sky130_fd_pr__nfet_01v8 ad=0.0567 pd=0.69 as=0.1176 ps=1.4 w=0.42 l=0.15
X137 a_2361_n1577# x2.x6.Y VDD.t92 VDD.t91 sky130_fd_pr__pfet_01v8_hvt ad=0.0567 pd=0.69 as=0.1176 ps=1.4 w=0.42 l=0.15
X138 x10.B a_2498_n477# VDD.t64 VDD.t63 sky130_fd_pr__pfet_01v8_hvt ad=0.34 pd=2.68 as=0.14575 ps=1.335 w=1 l=0.15
X139 x2.x5.Y A[11].t0 GND.t213 GND.t212 sky130_fd_pr__nfet_01v8 ad=0.169 pd=1.82 as=0.169 ps=1.82 w=0.65 l=0.15
X140 x5.A A[12].t3 GND.t120 GND.t119 sky130_fd_pr__nfet_01v8 ad=0.11863 pd=1.015 as=0.169 ps=1.82 w=0.65 l=0.15
X141 x16.A1 a_3281_n1577# VDD.t8 VDD.t7 sky130_fd_pr__pfet_01v8_hvt ad=0.475 pd=2.95 as=0.16655 ps=1.39 w=1 l=0.15
X142 x1.x2.Y A[14].t2 GND.t197 GND.t196 sky130_fd_pr__nfet_01v8 ad=0.08775 pd=0.92 as=0.169 ps=1.82 w=0.65 l=0.15
X143 x3.x7.X a_2361_n3277# GND.t130 GND.t129 sky130_fd_pr__nfet_01v8 ad=0.182 pd=1.86 as=0.1118 ps=1.04 w=0.65 l=0.15
X144 x1.x3.X a_898_345# VDD.t18 VDD.t17 sky130_fd_pr__pfet_01v8_hvt ad=0.34 pd=2.68 as=0.14575 ps=1.335 w=1 l=0.15
X145 GND.t34 x1.x3.X a_1435_123# GND.t33 sky130_fd_pr__nfet_01v8 ad=0.1118 pd=1.04 as=0.0567 ps=0.69 w=0.42 l=0.15
X146 GND.t100 x3.x7.X a_2830_n3055# GND.t99 sky130_fd_pr__nfet_01v8 ad=0.10025 pd=0.985 as=0.0567 ps=0.69 w=0.42 l=0.15
X147 a_3281_123# x1.x5.Y VDD.t38 VDD.t37 sky130_fd_pr__pfet_01v8_hvt ad=0.0567 pd=0.69 as=0.1176 ps=1.4 w=0.42 l=0.15
X148 a_2912_n4755# A[2].t1 a_2830_n4755# VDD.t262 sky130_fd_pr__pfet_01v8_hvt ad=0.0441 pd=0.63 as=0.1092 ps=1.36 w=0.42 l=0.15
X149 GND.t235 A[1].t2 a_898_n4755# GND.t234 sky130_fd_pr__nfet_01v8 ad=0.10025 pd=0.985 as=0.0567 ps=0.69 w=0.42 l=0.15
X150 a_2370_n3985# x16.A1 a_2512_n4137# GND.t72 sky130_fd_pr__nfet_01v8 ad=0.09975 pd=0.895 as=0.0693 ps=0.75 w=0.42 l=0.15
X151 x1.x3.X a_898_345# GND.t17 GND.t16 sky130_fd_pr__nfet_01v8 ad=0.169 pd=1.82 as=0.10025 ps=0.985 w=0.65 l=0.15
X152 x4.x2.Y A[2].t2 GND.t265 GND.t264 sky130_fd_pr__nfet_01v8 ad=0.08775 pd=0.92 as=0.169 ps=1.82 w=0.65 l=0.15
X153 a_898_345# A[12].t2 GND.t118 GND.t117 sky130_fd_pr__nfet_01v8 ad=0.0567 pd=0.69 as=0.1092 ps=1.36 w=0.42 l=0.15
X154 x6.Y x4.Z[2] VDD.t45 VDD.t44 sky130_fd_pr__pfet_01v8_hvt ad=0.135 pd=1.27 as=0.26 ps=2.52 w=1 l=0.15
X155 a_1435_n4977# x4.x2.Y a_1349_n4977# GND.t114 sky130_fd_pr__nfet_01v8 ad=0.0567 pd=0.69 as=0.1176 ps=1.4 w=0.42 l=0.15
X156 a_2733_n4137# x16.A0 a_2370_n3985# GND.t44 sky130_fd_pr__nfet_01v8 ad=0.0693 pd=0.75 as=0.09975 ps=0.895 w=0.42 l=0.15
X157 GND.t74 x2.x8.X a_3367_n1577# GND.t73 sky130_fd_pr__nfet_01v8 ad=0.1118 pd=1.04 as=0.0567 ps=0.69 w=0.42 l=0.15
X158 x4.x7.X a_2361_n4977# VDD.t126 VDD.t125 sky130_fd_pr__pfet_01v8_hvt ad=0.475 pd=2.95 as=0.16655 ps=1.39 w=1 l=0.15
X159 VDD.t132 x4.x7.X a_2912_n4755# VDD.t131 sky130_fd_pr__pfet_01v8_hvt ad=0.14575 pd=1.335 as=0.0441 ps=0.63 w=0.42 l=0.15
X160 GND.t105 a_2799_n4163# a_2733_n4137# GND.t104 sky130_fd_pr__nfet_01v8 ad=0.1449 pd=1.11 as=0.0693 ps=0.75 w=0.42 l=0.15
X161 a_1971_n4163# Y[2].t4 GND.t183 GND.t182 sky130_fd_pr__nfet_01v8 ad=0.1092 pd=1.36 as=0.1449 ps=1.11 w=0.42 l=0.15
X162 x16.A0 a_3281_123# VDD.t30 VDD.t29 sky130_fd_pr__pfet_01v8_hvt ad=0.475 pd=2.95 as=0.16655 ps=1.39 w=1 l=0.15
X163 a_65_n727# x5.A VDD.t24 VDD.t23 sky130_fd_pr__pfet_01v8_hvt ad=0.0735 pd=0.77 as=0.1092 ps=1.36 w=0.42 l=0.15
X164 a_203_n1355# A[8].t5 x2.Z[2] VDD.t177 sky130_fd_pr__pfet_01v8_hvt ad=0.13 pd=1.26 as=0.26 ps=2.52 w=1 l=0.15
X165 GND.t126 x10.B a_3035_n699# GND.t125 sky130_fd_pr__nfet_01v8 ad=0.1118 pd=1.04 as=0.0567 ps=0.69 w=0.42 l=0.15
X166 VDD.t100 a_1542_n2285# x14.X VDD.t99 sky130_fd_pr__pfet_01v8_hvt ad=0.15835 pd=1.395 as=0.26 ps=2.52 w=1 l=0.15
X167 a_2799_n2463# Y[2].t14 VDD.t186 VDD.t185 sky130_fd_pr__pfet_01v8_hvt ad=0.1176 pd=1.4 as=0.0693 ps=0.75 w=0.42 l=0.15
X168 GND.t122 A[12].t0 a_2447_123# GND.t121 sky130_fd_pr__nfet_01v8 ad=0.1118 pd=1.04 as=0.0567 ps=0.69 w=0.42 l=0.15
X169 Y[3].t0 a_985_n727# GND.t124 GND.t123 sky130_fd_pr__nfet_01v8 ad=0.169 pd=1.82 as=0.13165 ps=1.14 w=0.65 l=0.15
X170 x3.x5.Y A[7].t1 VDD.t255 VDD.t254 sky130_fd_pr__pfet_01v8_hvt ad=0.26 pd=2.52 as=0.26 ps=2.52 w=1 l=0.15
X171 x4.x3.X a_898_n4755# GND.t156 GND.t155 sky130_fd_pr__nfet_01v8 ad=0.169 pd=1.82 as=0.10025 ps=0.985 w=0.65 l=0.15
X172 x2.x8.X a_2830_n1355# VDD.t1 VDD.t0 sky130_fd_pr__pfet_01v8_hvt ad=0.34 pd=2.68 as=0.14575 ps=1.335 w=1 l=0.15
X173 a_3367_n1577# x2.x5.Y a_3281_n1577# GND.t71 sky130_fd_pr__nfet_01v8 ad=0.0567 pd=0.69 as=0.1176 ps=1.4 w=0.42 l=0.15
X174 VDD.t98 a_2370_n2285# x13.X VDD.t97 sky130_fd_pr__pfet_01v8_hvt ad=0.15835 pd=1.395 as=0.26 ps=2.52 w=1 l=0.15
X175 GND.t5 x3.x3.X a_1435_n3277# GND.t4 sky130_fd_pr__nfet_01v8 ad=0.1118 pd=1.04 as=0.0567 ps=0.69 w=0.42 l=0.15
X176 x6.Y x3.Z[2] a_795_n727# GND.t42 sky130_fd_pr__nfet_01v8 ad=0.169 pd=1.82 as=0.08775 ps=0.92 w=0.65 l=0.15
X177 VDD.t102 a_714_n2285# Y[1].t1 VDD.t101 sky130_fd_pr__pfet_01v8_hvt ad=0.15835 pd=1.395 as=0.26 ps=2.52 w=1 l=0.15
X178 GND.t253 A[0].t0 a_2447_n4977# GND.t252 sky130_fd_pr__nfet_01v8 ad=0.1118 pd=1.04 as=0.0567 ps=0.69 w=0.42 l=0.15
X179 x2.x7.X a_2361_n1577# GND.t12 GND.t11 sky130_fd_pr__nfet_01v8 ad=0.182 pd=1.86 as=0.1118 ps=1.04 w=0.65 l=0.15
X180 GND.t76 x2.x7.X a_2830_n1355# GND.t75 sky130_fd_pr__nfet_01v8 ad=0.10025 pd=0.985 as=0.0567 ps=0.69 w=0.42 l=0.15
X181 VDD.t142 x4.x8.X a_3281_n4977# VDD.t141 sky130_fd_pr__pfet_01v8_hvt ad=0.16655 pd=1.39 as=0.0567 ps=0.69 w=0.42 l=0.15
X182 a_2370_n2285# x13.A1 a_2512_n2437# GND.t67 sky130_fd_pr__nfet_01v8 ad=0.09975 pd=0.895 as=0.0693 ps=0.75 w=0.42 l=0.15
X183 GND.t217 A[5].t2 a_898_n3055# GND.t216 sky130_fd_pr__nfet_01v8 ad=0.10025 pd=0.985 as=0.0567 ps=0.69 w=0.42 l=0.15
X184 a_2447_n4977# x4.x6.Y a_2361_n4977# GND.t169 sky130_fd_pr__nfet_01v8 ad=0.0567 pd=0.69 as=0.1176 ps=1.4 w=0.42 l=0.15
X185 a_2115_n699# x3.Z[2] a_2029_n699# GND.t43 sky130_fd_pr__nfet_01v8 ad=0.0567 pd=0.69 as=0.1176 ps=1.4 w=0.42 l=0.15
X186 a_2733_n2437# x13.A0 a_2370_n2285# GND.t32 sky130_fd_pr__nfet_01v8 ad=0.0693 pd=0.75 as=0.09975 ps=0.895 w=0.42 l=0.15
X187 x3.x2.Y A[6].t2 GND.t223 GND.t222 sky130_fd_pr__nfet_01v8 ad=0.08775 pd=0.92 as=0.169 ps=1.82 w=0.65 l=0.15
X188 x4.Z[2] A[2].t3 GND.t263 GND.t262 sky130_fd_pr__nfet_01v8 ad=0.08775 pd=0.92 as=0.08937 ps=0.925 w=0.65 l=0.15
X189 a_2447_123# x1.x6.Y a_2361_123# GND.t30 sky130_fd_pr__nfet_01v8 ad=0.0567 pd=0.69 as=0.1176 ps=1.4 w=0.42 l=0.15
X190 Y[2].t1 a_2949_n699# GND.t52 GND.t51 sky130_fd_pr__nfet_01v8 ad=0.182 pd=1.86 as=0.1118 ps=1.04 w=0.65 l=0.15
X191 a_3281_n4977# x4.x5.Y VDD.t118 VDD.t117 sky130_fd_pr__pfet_01v8_hvt ad=0.0567 pd=0.69 as=0.1176 ps=1.4 w=0.42 l=0.15
X192 x8.Y x2.Z[2] VDD.t74 VDD.t73 sky130_fd_pr__pfet_01v8_hvt ad=0.26 pd=2.52 as=0.26 ps=2.52 w=1 l=0.15
X193 a_1971_n2463# Y[2].t12 GND.t171 GND.t170 sky130_fd_pr__nfet_01v8 ad=0.1092 pd=1.36 as=0.1449 ps=1.11 w=0.42 l=0.15
X194 GND.t92 a_2799_n2463# a_2733_n2437# GND.t91 sky130_fd_pr__nfet_01v8 ad=0.1449 pd=1.11 as=0.0693 ps=0.75 w=0.42 l=0.15
X195 a_2799_n4163# Y[2].t2 GND.t185 GND.t184 sky130_fd_pr__nfet_01v8 ad=0.1092 pd=1.36 as=0.1449 ps=1.11 w=0.42 l=0.15
X196 GND.t50 x6.Y a_1139_n727# GND.t49 sky130_fd_pr__nfet_01v8 ad=0.13165 pd=1.14 as=0.0441 ps=0.63 w=0.42 l=0.15
X197 a_2912_n3055# A[6].t1 a_2830_n3055# VDD.t229 sky130_fd_pr__pfet_01v8_hvt ad=0.0441 pd=0.63 as=0.1092 ps=1.36 w=0.42 l=0.15
X198 a_147_n727# x5.A a_65_n727# GND.t21 sky130_fd_pr__nfet_01v8 ad=0.0609 pd=0.71 as=0.1092 ps=1.36 w=0.42 l=0.15
X199 x2.x5.Y A[11].t1 VDD.t221 VDD.t220 sky130_fd_pr__pfet_01v8_hvt ad=0.26 pd=2.52 as=0.26 ps=2.52 w=1 l=0.15
X200 x3.x3.X a_898_n3055# GND.t94 GND.t93 sky130_fd_pr__nfet_01v8 ad=0.169 pd=1.82 as=0.10025 ps=0.985 w=0.65 l=0.15
X201 x4.x6.Y A[1].t0 GND.t237 GND.t236 sky130_fd_pr__nfet_01v8 ad=0.169 pd=1.82 as=0.169 ps=1.82 w=0.65 l=0.15
X202 VDD.t238 A[1].t4 a_980_n4755# VDD.t237 sky130_fd_pr__pfet_01v8_hvt ad=0.14575 pd=1.335 as=0.0441 ps=0.63 w=0.42 l=0.15
X203 GND.t239 A[15].t2 x1.x2.Y GND.t238 sky130_fd_pr__nfet_01v8 ad=0.169 pd=1.82 as=0.08775 ps=0.92 w=0.65 l=0.15
X204 GND.t69 x2.x3.X a_1435_n1577# GND.t68 sky130_fd_pr__nfet_01v8 ad=0.1118 pd=1.04 as=0.0567 ps=0.69 w=0.42 l=0.15
X205 a_1435_n3277# x3.x2.Y a_1349_n3277# GND.t145 sky130_fd_pr__nfet_01v8 ad=0.0567 pd=0.69 as=0.1176 ps=1.4 w=0.42 l=0.15
X206 GND.t231 A[3].t2 x4.x2.Y GND.t230 sky130_fd_pr__nfet_01v8 ad=0.169 pd=1.82 as=0.08775 ps=0.92 w=0.65 l=0.15
X207 a_663_n4755# A[2].t4 x4.x2.Y VDD.t261 sky130_fd_pr__pfet_01v8_hvt ad=0.105 pd=1.21 as=0.26 ps=2.52 w=1 l=0.15
X208 a_985_n727# x2.Z[2] VDD.t76 VDD.t75 sky130_fd_pr__pfet_01v8_hvt ad=0.06615 pd=0.735 as=0.0567 ps=0.69 w=0.42 l=0.15
X209 x3.x7.X a_2361_n3277# VDD.t144 VDD.t143 sky130_fd_pr__pfet_01v8_hvt ad=0.475 pd=2.95 as=0.16655 ps=1.39 w=1 l=0.15
X210 VDD.t114 x3.x7.X a_2912_n3055# VDD.t113 sky130_fd_pr__pfet_01v8_hvt ad=0.14575 pd=1.335 as=0.0441 ps=0.63 w=0.42 l=0.15
X211 a_898_n4755# A[0].t2 GND.t255 GND.t254 sky130_fd_pr__nfet_01v8 ad=0.0567 pd=0.69 as=0.1092 ps=1.36 w=0.42 l=0.15
X212 VDD.t140 x10.B a_2949_n699# VDD.t139 sky130_fd_pr__pfet_01v8_hvt ad=0.16655 pd=1.39 as=0.0567 ps=0.69 w=0.42 l=0.15
X213 VDD.t233 A[3].t4 a_663_n4755# VDD.t232 sky130_fd_pr__pfet_01v8_hvt ad=0.26 pd=2.52 as=0.105 ps=1.21 w=1 l=0.15
X214 VDD.t41 x1.x3.X a_1349_123# VDD.t40 sky130_fd_pr__pfet_01v8_hvt ad=0.16655 pd=1.39 as=0.0567 ps=0.69 w=0.42 l=0.15
X215 x1.x7.X a_2361_123# GND.t19 GND.t18 sky130_fd_pr__nfet_01v8 ad=0.182 pd=1.86 as=0.1118 ps=1.04 w=0.65 l=0.15
X216 a_341_n727# x3.Z[2] a_235_n727# GND.t41 sky130_fd_pr__nfet_01v8 ad=0.0693 pd=0.75 as=0.0798 ps=0.8 w=0.42 l=0.15
X217 x4.x3.X a_898_n4755# VDD.t171 VDD.t170 sky130_fd_pr__pfet_01v8_hvt ad=0.34 pd=2.68 as=0.14575 ps=1.335 w=1 l=0.15
X218 VDD.t148 x3.x8.X a_3281_n3277# VDD.t147 sky130_fd_pr__pfet_01v8_hvt ad=0.16655 pd=1.39 as=0.0567 ps=0.69 w=0.42 l=0.15
X219 a_203_345# A[12].t5 x5.A VDD.t133 sky130_fd_pr__pfet_01v8_hvt ad=0.13 pd=1.26 as=0.26 ps=2.52 w=1 l=0.15
X220 GND.t160 A[9].t2 a_898_n1355# GND.t159 sky130_fd_pr__nfet_01v8 ad=0.10025 pd=0.985 as=0.0567 ps=0.69 w=0.42 l=0.15
X221 a_1684_n3810# Y[2].t9 VDD.t190 VDD.t189 sky130_fd_pr__pfet_01v8_hvt ad=0.07665 pd=0.785 as=0.15835 ps=1.395 w=0.42 l=0.15
X222 a_1173_n3810# x17.X a_714_n3985# VDD.t149 sky130_fd_pr__pfet_01v8_hvt ad=0.0441 pd=0.63 as=0.1932 ps=1.34 w=0.42 l=0.15
X223 GND.t203 A[4].t0 a_2447_n3277# GND.t202 sky130_fd_pr__nfet_01v8 ad=0.1118 pd=1.04 as=0.0567 ps=0.69 w=0.42 l=0.15
X224 x3.Z[2] A[6].t3 GND.t221 GND.t220 sky130_fd_pr__nfet_01v8 ad=0.08775 pd=0.92 as=0.08937 ps=0.925 w=0.65 l=0.15
X225 a_1542_n3985# x17.A0 a_1684_n3810# VDD.t11 sky130_fd_pr__pfet_01v8_hvt ad=0.1932 pd=1.34 as=0.07665 ps=0.785 w=0.42 l=0.15
X226 Y[3].t1 a_985_n727# VDD.t138 VDD.t137 sky130_fd_pr__pfet_01v8_hvt ad=0.26 pd=2.52 as=0.14222 ps=1.335 w=1 l=0.15
X227 x2.x2.Y A[10].t2 GND.t249 GND.t248 sky130_fd_pr__nfet_01v8 ad=0.08775 pd=0.92 as=0.169 ps=1.82 w=0.65 l=0.15
X228 a_1435_123# x1.x2.Y a_1349_123# GND.t20 sky130_fd_pr__nfet_01v8 ad=0.0567 pd=0.69 as=0.1176 ps=1.4 w=0.42 l=0.15
X229 a_2830_345# A[14].t0 GND.t201 GND.t200 sky130_fd_pr__nfet_01v8 ad=0.0567 pd=0.69 as=0.1092 ps=1.36 w=0.42 l=0.15
X230 VDD.t128 x4.x3.X a_1349_n4977# VDD.t127 sky130_fd_pr__pfet_01v8_hvt ad=0.16655 pd=1.39 as=0.0567 ps=0.69 w=0.42 l=0.15
X231 a_2799_n2463# Y[2].t10 GND.t173 GND.t172 sky130_fd_pr__nfet_01v8 ad=0.1092 pd=1.36 as=0.1449 ps=1.11 w=0.42 l=0.15
X232 a_2512_n3810# Y[2].t7 VDD.t188 VDD.t187 sky130_fd_pr__pfet_01v8_hvt ad=0.07665 pd=0.785 as=0.15835 ps=1.395 w=0.42 l=0.15
X233 a_3281_n3277# x3.x5.Y VDD.t10 VDD.t9 sky130_fd_pr__pfet_01v8_hvt ad=0.0567 pd=0.69 as=0.1176 ps=1.4 w=0.42 l=0.15
X234 a_2370_n3985# x16.A0 a_2512_n3810# VDD.t54 sky130_fd_pr__pfet_01v8_hvt ad=0.1932 pd=1.34 as=0.07665 ps=0.785 w=0.42 l=0.15
X235 VDD.t200 a_1143_n4163# a_1173_n3810# VDD.t199 sky130_fd_pr__pfet_01v8_hvt ad=0.0693 pd=0.75 as=0.0441 ps=0.63 w=0.42 l=0.15
X236 x5.A A[14].t3 GND.t199 GND.t198 sky130_fd_pr__nfet_01v8 ad=0.08775 pd=0.92 as=0.08937 ps=0.925 w=0.65 l=0.15
X237 VDD.t136 A[12].t1 a_2361_123# VDD.t135 sky130_fd_pr__pfet_01v8_hvt ad=0.16655 pd=1.39 as=0.0567 ps=0.69 w=0.42 l=0.15
X238 x1.x8.X a_2830_345# VDD.t32 VDD.t31 sky130_fd_pr__pfet_01v8_hvt ad=0.34 pd=2.68 as=0.14575 ps=1.335 w=1 l=0.15
X239 a_2912_n1355# A[10].t1 a_2830_n1355# VDD.t249 sky130_fd_pr__pfet_01v8_hvt ad=0.0441 pd=0.63 as=0.1092 ps=1.36 w=0.42 l=0.15
X240 a_856_n3810# Y[3].t5 VDD.t206 VDD.t205 sky130_fd_pr__pfet_01v8_hvt ad=0.07665 pd=0.785 as=0.15835 ps=1.395 w=0.42 l=0.15
X241 a_714_n3985# x16.X a_856_n3810# VDD.t6 sky130_fd_pr__pfet_01v8_hvt ad=0.1932 pd=1.34 as=0.07665 ps=0.785 w=0.42 l=0.15
X242 a_2447_n3277# x3.x6.Y a_2361_n3277# GND.t131 sky130_fd_pr__nfet_01v8 ad=0.0567 pd=0.69 as=0.1176 ps=1.4 w=0.42 l=0.15
X243 x1.x6.Y A[13].t0 GND.t142 GND.t141 sky130_fd_pr__nfet_01v8 ad=0.169 pd=1.82 as=0.169 ps=1.82 w=0.65 l=0.15
X244 VDD.t51 x3.Z[2] x6.Y VDD.t50 sky130_fd_pr__pfet_01v8_hvt ad=0.26 pd=2.52 as=0.135 ps=1.27 w=1 l=0.15
X245 x2.x3.X a_898_n1355# GND.t66 GND.t65 sky130_fd_pr__nfet_01v8 ad=0.169 pd=1.82 as=0.10025 ps=0.985 w=0.65 l=0.15
X246 a_1435_n1577# x2.x2.Y a_1349_n1577# GND.t70 sky130_fd_pr__nfet_01v8 ad=0.0567 pd=0.69 as=0.1176 ps=1.4 w=0.42 l=0.15
X247 GND.t261 A[7].t2 x3.x2.Y GND.t260 sky130_fd_pr__nfet_01v8 ad=0.169 pd=1.82 as=0.08775 ps=0.92 w=0.65 l=0.15
X248 x3.x6.Y A[5].t0 GND.t219 GND.t218 sky130_fd_pr__nfet_01v8 ad=0.169 pd=1.82 as=0.169 ps=1.82 w=0.65 l=0.15
X249 x4.Z[1] a_1349_n4977# GND.t154 GND.t153 sky130_fd_pr__nfet_01v8 ad=0.182 pd=1.86 as=0.1118 ps=1.04 w=0.65 l=0.15
X250 GND.t227 A[3].t3 x4.Z[2] GND.t226 sky130_fd_pr__nfet_01v8 ad=0.169 pd=1.82 as=0.08775 ps=0.92 w=0.65 l=0.15
X251 a_980_n4755# A[0].t4 a_898_n4755# VDD.t251 sky130_fd_pr__pfet_01v8_hvt ad=0.0441 pd=0.63 as=0.1092 ps=1.36 w=0.42 l=0.15
X252 VDD.t167 a_1971_n4163# a_2001_n3810# VDD.t166 sky130_fd_pr__pfet_01v8_hvt ad=0.0693 pd=0.75 as=0.0441 ps=0.63 w=0.42 l=0.15
X253 a_2029_n699# x3.Z[2] VDD.t53 VDD.t52 sky130_fd_pr__pfet_01v8_hvt ad=0.0567 pd=0.69 as=0.1176 ps=1.4 w=0.42 l=0.15
X254 a_391_n4755# A[2].t5 a_285_n4755# VDD.t260 sky130_fd_pr__pfet_01v8_hvt ad=0.135 pd=1.27 as=0.19 ps=1.38 w=1 l=0.15
X255 x2.x7.X a_2361_n1577# VDD.t13 VDD.t12 sky130_fd_pr__pfet_01v8_hvt ad=0.475 pd=2.95 as=0.16655 ps=1.39 w=1 l=0.15
X256 x13.A0 a_1349_123# VDD.t16 VDD.t15 sky130_fd_pr__pfet_01v8_hvt ad=0.475 pd=2.95 as=0.16655 ps=1.39 w=1 l=0.15
X257 VDD.t90 x2.x7.X a_2912_n1355# VDD.t89 sky130_fd_pr__pfet_01v8_hvt ad=0.14575 pd=1.335 as=0.0441 ps=0.63 w=0.42 l=0.15
X258 a_1067_n727# x5.A a_985_n727# GND.t22 sky130_fd_pr__nfet_01v8 ad=0.0441 pd=0.63 as=0.1092 ps=1.36 w=0.42 l=0.15
X259 a_898_n3055# A[4].t2 GND.t207 GND.t206 sky130_fd_pr__nfet_01v8 ad=0.0567 pd=0.69 as=0.1092 ps=1.36 w=0.42 l=0.15
X260 VDD.t226 A[5].t4 a_980_n3055# VDD.t225 sky130_fd_pr__pfet_01v8_hvt ad=0.14575 pd=1.335 as=0.0441 ps=0.63 w=0.42 l=0.15
X261 a_663_n3055# A[6].t4 x3.x2.Y VDD.t228 sky130_fd_pr__pfet_01v8_hvt ad=0.105 pd=1.21 as=0.26 ps=2.52 w=1 l=0.15
X262 x4.Z[0] a_3281_n4977# GND.t107 GND.t106 sky130_fd_pr__nfet_01v8 ad=0.182 pd=1.86 as=0.1118 ps=1.04 w=0.65 l=0.15
X263 x4.x6.Y A[1].t1 VDD.t240 VDD.t239 sky130_fd_pr__pfet_01v8_hvt ad=0.26 pd=2.52 as=0.26 ps=2.52 w=1 l=0.15
X264 VDD.t34 x1.x7.X a_2912_345# VDD.t33 sky130_fd_pr__pfet_01v8_hvt ad=0.14575 pd=1.335 as=0.0441 ps=0.63 w=0.42 l=0.15
X265 GND.t60 x8.Y a_2498_n477# GND.t59 sky130_fd_pr__nfet_01v8 ad=0.10025 pd=0.985 as=0.0567 ps=0.69 w=0.42 l=0.15
X266 x1.x6.Y A[13].t1 VDD.t154 VDD.t153 sky130_fd_pr__pfet_01v8_hvt ad=0.26 pd=2.52 as=0.26 ps=2.52 w=1 l=0.15
X267 Y[2].t0 a_2949_n699# VDD.t62 VDD.t61 sky130_fd_pr__pfet_01v8_hvt ad=0.475 pd=2.95 as=0.16655 ps=1.39 w=1 l=0.15
X268 a_2001_n3810# x4.Z[0] a_1542_n3985# VDD.t165 sky130_fd_pr__pfet_01v8_hvt ad=0.0441 pd=0.63 as=0.1932 ps=1.34 w=0.42 l=0.15
X269 a_1143_n4163# Y[3].t4 VDD.t208 VDD.t207 sky130_fd_pr__pfet_01v8_hvt ad=0.1176 pd=1.4 as=0.0693 ps=0.75 w=0.42 l=0.15
X270 GND.t168 A[8].t0 a_2447_n1577# GND.t167 sky130_fd_pr__nfet_01v8 ad=0.1118 pd=1.04 as=0.0567 ps=0.69 w=0.42 l=0.15
X271 a_2361_123# x1.x6.Y VDD.t36 VDD.t35 sky130_fd_pr__pfet_01v8_hvt ad=0.0567 pd=0.69 as=0.1176 ps=1.4 w=0.42 l=0.15
X272 x2.Z[2] A[10].t3 GND.t247 GND.t246 sky130_fd_pr__nfet_01v8 ad=0.08775 pd=0.92 as=0.08937 ps=0.925 w=0.65 l=0.15
X273 VDD.t259 A[7].t4 a_663_n3055# VDD.t258 sky130_fd_pr__pfet_01v8_hvt ad=0.26 pd=2.52 as=0.105 ps=1.21 w=1 l=0.15
X274 x3.x3.X a_898_n3055# VDD.t109 VDD.t108 sky130_fd_pr__pfet_01v8_hvt ad=0.34 pd=2.68 as=0.14575 ps=1.335 w=1 l=0.15
X275 a_1349_n4977# x4.x2.Y VDD.t130 VDD.t129 sky130_fd_pr__pfet_01v8_hvt ad=0.0567 pd=0.69 as=0.1176 ps=1.4 w=0.42 l=0.15
X276 Y[4].t0 a_65_n727# GND.t48 GND.t47 sky130_fd_pr__nfet_01v8 ad=0.169 pd=1.82 as=0.19627 ps=1.33 w=0.65 l=0.15
X277 a_3035_n699# x5.A a_2949_n699# GND.t23 sky130_fd_pr__nfet_01v8 ad=0.0567 pd=0.69 as=0.1176 ps=1.4 w=0.42 l=0.15
X278 VDD.t88 x2.x8.X a_3281_n1577# VDD.t87 sky130_fd_pr__pfet_01v8_hvt ad=0.16655 pd=1.39 as=0.0567 ps=0.69 w=0.42 l=0.15
X279 VDD.t5 x3.x3.X a_1349_n3277# VDD.t4 sky130_fd_pr__pfet_01v8_hvt ad=0.16655 pd=1.39 as=0.0567 ps=0.69 w=0.42 l=0.15
X280 x13.A0 a_1349_123# GND.t15 GND.t14 sky130_fd_pr__nfet_01v8 ad=0.182 pd=1.86 as=0.1118 ps=1.04 w=0.65 l=0.15
X281 a_1173_n2110# x14.X a_714_n2285# VDD.t96 sky130_fd_pr__pfet_01v8_hvt ad=0.0441 pd=0.63 as=0.1932 ps=1.34 w=0.42 l=0.15
X282 a_1684_n2110# Y[2].t17 VDD.t192 VDD.t191 sky130_fd_pr__pfet_01v8_hvt ad=0.07665 pd=0.785 as=0.15835 ps=1.395 w=0.42 l=0.15
X283 x1.x7.X a_2361_123# VDD.t20 VDD.t19 sky130_fd_pr__pfet_01v8_hvt ad=0.475 pd=2.95 as=0.16655 ps=1.39 w=1 l=0.15
X284 GND.t58 x9.Y a_2115_n699# GND.t57 sky130_fd_pr__nfet_01v8 ad=0.1118 pd=1.04 as=0.0567 ps=0.69 w=0.42 l=0.15
X285 x2.x6.Y A[9].t0 GND.t162 GND.t161 sky130_fd_pr__nfet_01v8 ad=0.169 pd=1.82 as=0.169 ps=1.82 w=0.65 l=0.15
X286 a_2447_n1577# x2.x6.Y a_2361_n1577# GND.t77 sky130_fd_pr__nfet_01v8 ad=0.0567 pd=0.69 as=0.1176 ps=1.4 w=0.42 l=0.15
X287 a_1542_n2285# x3.Z[1] a_1684_n2110# VDD.t14 sky130_fd_pr__pfet_01v8_hvt ad=0.1932 pd=1.34 as=0.07665 ps=0.785 w=0.42 l=0.15
X288 x3.Z[1] a_1349_n3277# GND.t98 GND.t97 sky130_fd_pr__nfet_01v8 ad=0.182 pd=1.86 as=0.1118 ps=1.04 w=0.65 l=0.15
X289 x4.Z[2] A[0].t3 GND.t251 GND.t250 sky130_fd_pr__nfet_01v8 ad=0.11863 pd=1.015 as=0.169 ps=1.82 w=0.65 l=0.15
X290 a_285_n4755# A[1].t5 a_203_n4755# VDD.t236 sky130_fd_pr__pfet_01v8_hvt ad=0.19 pd=1.38 as=0.13 ps=1.26 w=1 l=0.15
X291 VDD.t120 a_2799_n4163# a_2829_n3810# VDD.t119 sky130_fd_pr__pfet_01v8_hvt ad=0.0693 pd=0.75 as=0.0441 ps=0.63 w=0.42 l=0.15
X292 VDD.t242 A[15].t5 a_391_345# VDD.t241 sky130_fd_pr__pfet_01v8_hvt ad=0.26 pd=2.52 as=0.135 ps=1.27 w=1 l=0.15
X293 GND.t211 A[11].t2 x2.x2.Y GND.t210 sky130_fd_pr__nfet_01v8 ad=0.169 pd=1.82 as=0.08775 ps=0.92 w=0.65 l=0.15
X294 GND.t259 A[7].t3 x3.Z[2] GND.t258 sky130_fd_pr__nfet_01v8 ad=0.169 pd=1.82 as=0.08775 ps=0.92 w=0.65 l=0.15
X295 a_1077_n4137# x16.X a_714_n3985# GND.t6 sky130_fd_pr__nfet_01v8 ad=0.0693 pd=0.75 as=0.09975 ps=0.895 w=0.42 l=0.15
X296 VDD.t60 x6.Y a_985_n727# VDD.t59 sky130_fd_pr__pfet_01v8_hvt ad=0.14222 pd=1.335 as=0.06615 ps=0.735 w=0.42 l=0.15
X297 GND.t233 A[1].t3 x4.Z[2] GND.t232 sky130_fd_pr__nfet_01v8 ad=0.08937 pd=0.925 as=0.11863 ps=1.015 w=0.65 l=0.15
X298 a_3281_n1577# x2.x5.Y VDD.t85 VDD.t84 sky130_fd_pr__pfet_01v8_hvt ad=0.0567 pd=0.69 as=0.1176 ps=1.4 w=0.42 l=0.15
X299 a_2512_n2110# Y[2].t15 VDD.t194 VDD.t193 sky130_fd_pr__pfet_01v8_hvt ad=0.07665 pd=0.785 as=0.15835 ps=1.395 w=0.42 l=0.15
R0 A[3].n0 A[3].t4 231.835
R1 A[3].n4 A[3].t1 230.576
R2 A[3].n2 A[3].t5 230.155
R3 A[3].n3 A[3].n2 167.508
R4 A[3].n4 A[3].t0 158.275
R5 A[3].n2 A[3].t3 157.856
R6 A[3].n0 A[3].t2 157.07
R7 A[3].n5 A[3].n4 155.733
R8 A[3].n1 A[3].n0 152
R9 A[3].n6 A[3].n5 15.7314
R10 A[3].n6 A[3].n1 11.6337
R11 A[3].n6 A[3].n3 9.3005
R12 A[3].n3 A[3] 3.93896
R13 A[3].n5 A[3] 2.93383
R14 A[3] A[3].n6 2.02478
R15 A[3].n1 A[3] 2.01193
R16 A[2].n5 A[2].t5 241.536
R17 A[2].n0 A[2].t4 230.363
R18 A[2].n2 A[2].t0 192.639
R19 A[2] A[2].n5 188.722
R20 A[2].n5 A[2].t3 169.237
R21 A[2].n0 A[2].t2 158.064
R22 A[2].n3 A[2].n2 154.058
R23 A[2].n1 A[2].n0 153.792
R24 A[2].n2 A[2].t1 134.799
R25 A[2].n4 A[2].n3 26.9626
R26 A[2].n6 A[2] 14.1005
R27 A[2].n4 A[2].n1 10.2939
R28 A[2].n1 A[2] 4.6085
R29 A[2].n3 A[2] 4.11479
R30 A[2] A[2].n6 1.66214
R31 A[2].n6 A[2].n4 0.00233824
R32 A[1].n5 A[1].t5 241.536
R33 A[1].n0 A[1].t1 230.576
R34 A[1].n2 A[1].t2 206.19
R35 A[1].n5 A[1].t3 169.237
R36 A[1] A[1].n5 167.065
R37 A[1].n0 A[1].t0 158.275
R38 A[1].n1 A[1].n0 155.201
R39 A[1].n3 A[1].n2 152
R40 A[1].n2 A[1].t4 148.35
R41 A[1].n4 A[1].n1 17.349
R42 A[1].n4 A[1].n3 14.9456
R43 A[1].n6 A[1] 11.6278
R44 A[1].n6 A[1].n4 6.9196
R45 A[1].n1 A[1] 3.46717
R46 A[1] A[1].n6 1.27863
R47 A[1].n3 A[1] 0.686214
R48 A[0].n4 A[0].t1 261.887
R49 A[0].n0 A[0].t5 230.155
R50 A[0].n2 A[0].t2 192.639
R51 A[0].n0 A[0].t3 157.856
R52 A[0].n4 A[0].t0 155.847
R53 A[0].n3 A[0].n2 153.601
R54 A[0].n5 A[0].n4 152.768
R55 A[0].n1 A[0].n0 152
R56 A[0].n2 A[0].t4 134.799
R57 A[0].n6 A[0].n5 23.7395
R58 A[0].n6 A[0].n3 16.2762
R59 A[0].n7 A[0].n1 10.5872
R60 A[0].n3 A[0] 4.57193
R61 A[0].n7 A[0].n6 4.53091
R62 A[0].n5 A[0] 4.0965
R63 A[0].n1 A[0] 2.8165
R64 A[0] A[0].n7 0.497524
R65 Y[0].n1 Y[0] 593.216
R66 Y[0].n1 Y[0].n0 585
R67 Y[0].n2 Y[0].n1 585
R68 Y[0].n4 Y[0].t1 209.923
R69 Y[0].n3 Y[0].n2 69.803
R70 Y[0].n1 Y[0].t0 26.5955
R71 Y[0].n3 Y[0] 9.91573
R72 Y[0].n0 Y[0] 8.21543
R73 Y[0].n0 Y[0] 4.77662
R74 Y[0].n2 Y[0] 4.77662
R75 Y[0].n4 Y[0].n3 4.51815
R76 Y[0] Y[0].n4 2.5103
R77 A[7].n0 A[7].t4 231.835
R78 A[7].n4 A[7].t1 230.576
R79 A[7].n2 A[7].t5 230.155
R80 A[7].n3 A[7].n2 167.508
R81 A[7].n4 A[7].t0 158.275
R82 A[7].n2 A[7].t3 157.856
R83 A[7].n0 A[7].t2 157.07
R84 A[7].n5 A[7].n4 155.733
R85 A[7].n1 A[7].n0 152
R86 A[7].n6 A[7].n5 15.7314
R87 A[7].n6 A[7].n1 11.6337
R88 A[7].n6 A[7].n3 9.3005
R89 A[7].n3 A[7] 3.93896
R90 A[7].n5 A[7] 2.93383
R91 A[7] A[7].n6 2.02478
R92 A[7].n1 A[7] 2.01193
R93 A[6].n5 A[6].t5 241.536
R94 A[6].n0 A[6].t4 230.363
R95 A[6].n2 A[6].t0 192.639
R96 A[6] A[6].n5 188.722
R97 A[6].n5 A[6].t3 169.237
R98 A[6].n0 A[6].t2 158.064
R99 A[6].n3 A[6].n2 154.058
R100 A[6].n1 A[6].n0 153.792
R101 A[6].n2 A[6].t1 134.799
R102 A[6].n4 A[6].n3 26.9626
R103 A[6].n6 A[6] 14.1005
R104 A[6].n4 A[6].n1 10.2939
R105 A[6].n1 A[6] 4.6085
R106 A[6].n3 A[6] 4.11479
R107 A[6] A[6].n6 1.66214
R108 A[6].n6 A[6].n4 0.00233824
R109 A[5].n5 A[5].t5 241.536
R110 A[5].n0 A[5].t1 230.576
R111 A[5].n2 A[5].t2 206.19
R112 A[5].n5 A[5].t3 169.237
R113 A[5] A[5].n5 167.065
R114 A[5].n0 A[5].t0 158.275
R115 A[5].n1 A[5].n0 155.201
R116 A[5].n3 A[5].n2 152
R117 A[5].n2 A[5].t4 148.35
R118 A[5].n4 A[5].n1 17.349
R119 A[5].n4 A[5].n3 14.9456
R120 A[5].n6 A[5] 11.6278
R121 A[5].n6 A[5].n4 6.9196
R122 A[5].n1 A[5] 3.46717
R123 A[5] A[5].n6 1.27863
R124 A[5].n3 A[5] 0.686214
R125 A[4].n4 A[4].t1 261.887
R126 A[4].n0 A[4].t5 230.155
R127 A[4].n2 A[4].t2 192.639
R128 A[4].n0 A[4].t3 157.856
R129 A[4].n4 A[4].t0 155.847
R130 A[4].n3 A[4].n2 153.601
R131 A[4].n5 A[4].n4 152.768
R132 A[4].n1 A[4].n0 152
R133 A[4].n2 A[4].t4 134.799
R134 A[4].n6 A[4].n5 23.7395
R135 A[4].n6 A[4].n3 16.2762
R136 A[4].n7 A[4].n1 10.5872
R137 A[4].n3 A[4] 4.57193
R138 A[4].n7 A[4].n6 4.53091
R139 A[4].n5 A[4] 4.0965
R140 A[4].n1 A[4] 2.8165
R141 A[4] A[4].n7 0.497524
R142 Y[1].n1 Y[1] 593.216
R143 Y[1].n1 Y[1].n0 585
R144 Y[1].n2 Y[1].n1 585
R145 Y[1].n4 Y[1].t0 209.923
R146 Y[1].n3 Y[1].n2 69.3011
R147 Y[1].n1 Y[1].t1 26.5955
R148 Y[1].n3 Y[1] 9.9255
R149 Y[1].n0 Y[1] 8.21543
R150 Y[1].n4 Y[1].n3 5.02011
R151 Y[1].n0 Y[1] 4.77662
R152 Y[1].n2 Y[1] 4.77662
R153 Y[1] Y[1].n4 2.5103
R154 A[11].n0 A[11].t4 231.835
R155 A[11].n4 A[11].t1 230.576
R156 A[11].n2 A[11].t5 230.155
R157 A[11].n3 A[11].n2 167.508
R158 A[11].n4 A[11].t0 158.275
R159 A[11].n2 A[11].t3 157.856
R160 A[11].n0 A[11].t2 157.07
R161 A[11].n5 A[11].n4 155.733
R162 A[11].n1 A[11].n0 152
R163 A[11].n6 A[11].n5 15.7314
R164 A[11].n6 A[11].n1 11.6337
R165 A[11].n6 A[11].n3 9.3005
R166 A[11].n3 A[11] 3.93896
R167 A[11].n5 A[11] 2.93383
R168 A[11] A[11].n6 2.02478
R169 A[11].n1 A[11] 2.01193
R170 A[10].n5 A[10].t5 241.536
R171 A[10].n0 A[10].t4 230.363
R172 A[10].n2 A[10].t0 192.639
R173 A[10] A[10].n5 188.722
R174 A[10].n5 A[10].t3 169.237
R175 A[10].n0 A[10].t2 158.064
R176 A[10].n3 A[10].n2 154.058
R177 A[10].n1 A[10].n0 153.792
R178 A[10].n2 A[10].t1 134.799
R179 A[10].n4 A[10].n3 26.9626
R180 A[10].n6 A[10] 14.1005
R181 A[10].n4 A[10].n1 10.2939
R182 A[10].n1 A[10] 4.6085
R183 A[10].n3 A[10] 4.11479
R184 A[10] A[10].n6 1.66214
R185 A[10].n6 A[10].n4 0.00233824
R186 A[9].n5 A[9].t5 241.536
R187 A[9].n0 A[9].t1 230.576
R188 A[9].n2 A[9].t2 206.19
R189 A[9].n5 A[9].t3 169.237
R190 A[9] A[9].n5 167.065
R191 A[9].n0 A[9].t0 158.275
R192 A[9].n1 A[9].n0 155.201
R193 A[9].n3 A[9].n2 152
R194 A[9].n2 A[9].t4 148.35
R195 A[9].n4 A[9].n1 17.349
R196 A[9].n4 A[9].n3 14.9456
R197 A[9].n6 A[9] 11.6278
R198 A[9].n6 A[9].n4 6.9196
R199 A[9].n1 A[9] 3.46717
R200 A[9] A[9].n6 1.27863
R201 A[9].n3 A[9] 0.686214
R202 A[8].n4 A[8].t1 261.887
R203 A[8].n0 A[8].t5 230.155
R204 A[8].n2 A[8].t2 192.639
R205 A[8].n0 A[8].t3 157.856
R206 A[8].n4 A[8].t0 155.847
R207 A[8].n3 A[8].n2 153.601
R208 A[8].n5 A[8].n4 152.768
R209 A[8].n1 A[8].n0 152
R210 A[8].n2 A[8].t4 134.799
R211 A[8].n6 A[8].n5 23.7395
R212 A[8].n6 A[8].n3 16.2762
R213 A[8].n7 A[8].n1 10.5872
R214 A[8].n3 A[8] 4.57193
R215 A[8].n7 A[8].n6 4.53091
R216 A[8].n5 A[8] 4.0965
R217 A[8].n1 A[8] 2.8165
R218 A[8] A[8].n7 0.497524
R219 Y[2].n2 Y[2] 590.984
R220 Y[2].n3 Y[2].n2 585
R221 Y[2] Y[2].n10 428.005
R222 Y[2] Y[2].n7 428.005
R223 Y[2] Y[2].n15 428.005
R224 Y[2] Y[2].n1 428.005
R225 Y[2].n11 Y[2].t10 329.902
R226 Y[2].n8 Y[2].t12 329.902
R227 Y[2].n16 Y[2].t2 329.902
R228 Y[2].n0 Y[2].t4 329.902
R229 Y[2].n10 Y[2].t15 272.062
R230 Y[2].n7 Y[2].t17 272.062
R231 Y[2].n15 Y[2].t7 272.062
R232 Y[2].n1 Y[2].t9 272.062
R233 Y[2] Y[2].t1 269.426
R234 Y[2].n10 Y[2].t11 206.19
R235 Y[2].n7 Y[2].t13 206.19
R236 Y[2].n15 Y[2].t3 206.19
R237 Y[2].n1 Y[2].t5 206.19
R238 Y[2] Y[2].n0 152.674
R239 Y[2].n12 Y[2].n11 152
R240 Y[2].n9 Y[2].n8 152
R241 Y[2].n17 Y[2].n16 152
R242 Y[2].n11 Y[2].t14 148.35
R243 Y[2].n8 Y[2].t16 148.35
R244 Y[2].n16 Y[2].t6 148.35
R245 Y[2].n0 Y[2].t8 148.35
R246 Y[2].n2 Y[2].t0 46.2955
R247 Y[2].n19 Y[2] 24.59
R248 Y[2].n19 Y[2].n18 21.5192
R249 Y[2].n13 Y[2].n9 18.5843
R250 Y[2].n13 Y[2].n12 14.0603
R251 Y[2].n6 Y[2] 13.3125
R252 Y[2] Y[2].n5 11.2645
R253 Y[2].n18 Y[2].n14 11.236
R254 Y[2].n18 Y[2].n17 10.9847
R255 Y[2] Y[2].n6 9.77685
R256 Y[2].n14 Y[2] 9.13002
R257 Y[2].n14 Y[2].n13 8.45362
R258 Y[2] Y[2].n4 6.6565
R259 Y[2] Y[2].n19 6.4005
R260 Y[2].n5 Y[2] 6.1445
R261 Y[2].n5 Y[2] 4.63498
R262 Y[2].n6 Y[2] 4.0965
R263 Y[2].n4 Y[2] 3.61789
R264 Y[2].n3 Y[2] 3.47876
R265 Y[2].n4 Y[2].n3 2.36572
R266 Y[2].n9 Y[2] 0.674184
R267 Y[2].n17 Y[2] 0.674184
R268 Y[2].n12 Y[2] 0.492808
R269 Y[3] Y[3].n0 591.75
R270 Y[3].n2 Y[3].n0 585
R271 Y[3] Y[3].n4 428.005
R272 Y[3] Y[3].n6 428.005
R273 Y[3].n3 Y[3].t6 329.902
R274 Y[3].n7 Y[3].t2 329.902
R275 Y[3].n4 Y[3].t9 272.062
R276 Y[3].n6 Y[3].t5 272.062
R277 Y[3].n1 Y[3].t0 209.923
R278 Y[3].n4 Y[3].t7 206.19
R279 Y[3].n6 Y[3].t3 206.19
R280 Y[3] Y[3].n3 152.674
R281 Y[3].n8 Y[3].n7 152
R282 Y[3].n3 Y[3].t8 148.35
R283 Y[3].n7 Y[3].t4 148.35
R284 Y[3].n2 Y[3].n1 96.3104
R285 Y[3].n0 Y[3].t1 26.5955
R286 Y[3].n9 Y[3].n8 24.0608
R287 Y[3].n9 Y[3].n5 23.5564
R288 Y[3] Y[3].n9 19.2556
R289 Y[3].n5 Y[3] 18.5268
R290 Y[3].n10 Y[3] 14.5253
R291 Y[3].n5 Y[3] 12.4637
R292 Y[3].n10 Y[3].n2 4.88777
R293 Y[3] Y[3].n10 4.18959
R294 Y[3].n1 Y[3] 4.18512
R295 Y[3].n8 Y[3] 0.674184
R296 Y[4].n3 Y[4].n2 590.082
R297 Y[4].n3 Y[4].n1 585
R298 Y[4].n4 Y[4].n3 585
R299 Y[4].n5 Y[4].t0 129.381
R300 Y[4].n3 Y[4].t1 26.5955
R301 Y[4].n0 Y[4] 14.8341
R302 Y[4] Y[4].n6 14.7697
R303 Y[4].n1 Y[4] 10.5851
R304 Y[4] Y[4].n4 10.5851
R305 Y[4] Y[4].n5 7.0214
R306 Y[4] Y[4].n1 6.15435
R307 Y[4].n5 Y[4] 5.55208
R308 Y[4].n2 Y[4] 3.93896
R309 Y[4] Y[4].n0 3.93896
R310 Y[4].n2 Y[4] 3.01226
R311 Y[4].n4 Y[4].n0 2.21588
R312 Y[4].n6 Y[4] 1.96973
R313 Y[4].n6 Y[4] 1.50638
R314 A[15].n0 A[15].t4 231.835
R315 A[15].n4 A[15].t1 230.576
R316 A[15].n2 A[15].t5 230.155
R317 A[15].n3 A[15].n2 167.508
R318 A[15].n4 A[15].t0 158.275
R319 A[15].n2 A[15].t3 157.856
R320 A[15].n0 A[15].t2 157.07
R321 A[15].n5 A[15].n4 155.733
R322 A[15].n1 A[15].n0 152
R323 A[15].n6 A[15].n5 15.7314
R324 A[15].n6 A[15].n1 11.6337
R325 A[15].n6 A[15].n3 9.3005
R326 A[15].n3 A[15] 3.93896
R327 A[15].n5 A[15] 2.93383
R328 A[15] A[15].n6 2.02478
R329 A[15].n1 A[15] 2.01193
R330 A[14].n5 A[14].t5 241.536
R331 A[14].n0 A[14].t4 230.363
R332 A[14].n2 A[14].t0 192.639
R333 A[14] A[14].n5 188.722
R334 A[14].n5 A[14].t3 169.237
R335 A[14].n0 A[14].t2 158.064
R336 A[14].n3 A[14].n2 154.058
R337 A[14].n1 A[14].n0 153.792
R338 A[14].n2 A[14].t1 134.799
R339 A[14].n4 A[14].n3 26.9626
R340 A[14].n6 A[14] 14.1005
R341 A[14].n4 A[14].n1 10.2939
R342 A[14].n1 A[14] 4.6085
R343 A[14].n3 A[14] 4.11479
R344 A[14] A[14].n6 1.66214
R345 A[14].n6 A[14].n4 0.00233824
R346 A[13].n5 A[13].t5 241.536
R347 A[13].n0 A[13].t1 230.576
R348 A[13].n2 A[13].t2 206.19
R349 A[13].n5 A[13].t3 169.237
R350 A[13] A[13].n5 167.065
R351 A[13].n0 A[13].t0 158.275
R352 A[13].n1 A[13].n0 155.201
R353 A[13].n3 A[13].n2 152
R354 A[13].n2 A[13].t4 148.35
R355 A[13].n4 A[13].n1 17.349
R356 A[13].n4 A[13].n3 14.9456
R357 A[13].n6 A[13] 11.6278
R358 A[13].n6 A[13].n4 6.9196
R359 A[13].n1 A[13] 3.46717
R360 A[13] A[13].n6 1.27863
R361 A[13].n3 A[13] 0.686214
R362 A[12].n4 A[12].t1 261.887
R363 A[12].n0 A[12].t5 230.155
R364 A[12].n2 A[12].t2 192.639
R365 A[12].n0 A[12].t3 157.856
R366 A[12].n4 A[12].t0 155.847
R367 A[12].n3 A[12].n2 153.601
R368 A[12].n5 A[12].n4 152.768
R369 A[12].n1 A[12].n0 152
R370 A[12].n2 A[12].t4 134.799
R371 A[12].n6 A[12].n5 23.7395
R372 A[12].n6 A[12].n3 16.2762
R373 A[12].n7 A[12].n1 10.5872
R374 A[12].n3 A[12] 4.57193
R375 A[12].n7 A[12].n6 4.53091
R376 A[12].n5 A[12] 4.0965
R377 A[12].n1 A[12] 2.8165
R378 A[12] A[12].n7 0.497524
R379 VDD.t46 VDD.t73 834.58
R380 VDD.n27 VDD.t61 757.668
R381 VDD.n128 VDD.t29 757.668
R382 VDD.n47 VDD.t7 757.668
R383 VDD.n217 VDD.t2 757.668
R384 VDD.n241 VDD.t121 757.668
R385 VDD.n556 VDD.n11 717.729
R386 VDD.n15 VDD.t53 675.293
R387 VDD.n34 VDD.t26 675.293
R388 VDD.n179 VDD.t22 675.293
R389 VDD.n198 VDD.t36 675.293
R390 VDD.n124 VDD.t38 675.293
R391 VDD.n95 VDD.t83 675.293
R392 VDD.n114 VDD.t92 675.293
R393 VDD.n54 VDD.t85 675.293
R394 VDD.n423 VDD.t160 675.293
R395 VDD.n442 VDD.t146 675.293
R396 VDD.n224 VDD.t10 675.293
R397 VDD.n289 VDD.t130 675.293
R398 VDD.n308 VDD.t182 675.293
R399 VDD.n248 VDD.t118 675.293
R400 VDD.n572 VDD.t24 662.841
R401 VDD.t39 VDD.t79 633.333
R402 VDD.t183 VDD 633.333
R403 VDD.t14 VDD.t105 633.333
R404 VDD.t203 VDD 633.333
R405 VDD.t95 VDD.t96 633.333
R406 VDD.t54 VDD.t86 633.333
R407 VDD.t195 VDD 633.333
R408 VDD.t11 VDD.t165 633.333
R409 VDD.t207 VDD 633.333
R410 VDD.t6 VDD.t149 633.333
R411 VDD.n472 VDD.n471 629.801
R412 VDD.n504 VDD.n464 629.801
R413 VDD.n453 VDD.n452 629.801
R414 VDD.n355 VDD.n337 629.801
R415 VDD.n331 VDD.n330 629.801
R416 VDD.n323 VDD.n321 629.801
R417 VDD.n558 VDD.n9 611.178
R418 VDD.n570 VDD.n2 599.74
R419 VDD.n476 VDD 568.26
R420 VDD.n343 VDD 568.26
R421 VDD VDD.t63 547.509
R422 VDD VDD.t31 547.509
R423 VDD VDD.t17 547.509
R424 VDD VDD.t0 547.509
R425 VDD VDD.t77 547.509
R426 VDD VDD.t161 547.509
R427 VDD VDD.t108 547.509
R428 VDD VDD.t123 547.509
R429 VDD VDD.t170 547.509
R430 VDD VDD.t153 503.115
R431 VDD VDD.t245 503.115
R432 VDD VDD.t175 503.115
R433 VDD VDD.t220 503.115
R434 VDD VDD.t223 503.115
R435 VDD VDD.t254 503.115
R436 VDD VDD.t239 503.115
R437 VDD VDD.t234 503.115
R438 VDD VDD.t65 494.238
R439 VDD VDD.t19 494.238
R440 VDD VDD.t15 494.238
R441 VDD VDD.t12 494.238
R442 VDD VDD.t157 494.238
R443 VDD VDD.t143 494.238
R444 VDD VDD.t111 494.238
R445 VDD VDD.t125 494.238
R446 VDD VDD.t168 494.238
R447 VDD.t57 VDD.t42 491.277
R448 VDD VDD.t243 411.372
R449 VDD VDD.t216 411.372
R450 VDD VDD.t258 411.372
R451 VDD VDD.t232 411.372
R452 VDD VDD.t241 366.978
R453 VDD VDD.t218 366.978
R454 VDD VDD.t256 366.978
R455 VDD VDD.t230 366.978
R456 VDD VDD.t137 364.019
R457 VDD VDD.t50 364.019
R458 VDD VDD.t57 361.06
R459 VDD.n78 VDD.t219 341.93
R460 VDD.n406 VDD.t257 341.93
R461 VDD.n272 VDD.t231 341.93
R462 VDD.n162 VDD.t242 341.928
R463 VDD.n537 VDD.n17 325.627
R464 VDD.n25 VDD.n24 325.627
R465 VDD.n157 VDD.n156 325.627
R466 VDD.n149 VDD.n120 325.627
R467 VDD.n132 VDD.n126 325.627
R468 VDD.n73 VDD.n72 325.627
R469 VDD.n65 VDD.n64 325.627
R470 VDD.n45 VDD.n44 325.627
R471 VDD.n401 VDD.n400 325.627
R472 VDD.n393 VDD.n208 325.627
R473 VDD.n215 VDD.n214 325.627
R474 VDD.n267 VDD.n266 325.627
R475 VDD.n259 VDD.n258 325.627
R476 VDD.n239 VDD.n238 325.627
R477 VDD.t97 VDD.t193 322.587
R478 VDD.t99 VDD.t191 322.587
R479 VDD.t101 VDD.t201 322.587
R480 VDD.t150 VDD.t187 322.587
R481 VDD.t115 VDD.t189 322.587
R482 VDD.t163 VDD.t205 322.587
R483 VDD.t61 VDD.t139 319.627
R484 VDD.t65 VDD.t67 319.627
R485 VDD.t29 VDD.t55 319.627
R486 VDD.t19 VDD.t135 319.627
R487 VDD.t15 VDD.t40 319.627
R488 VDD.t7 VDD.t87 319.627
R489 VDD.t12 VDD.t179 319.627
R490 VDD.t157 VDD.t80 319.627
R491 VDD.t2 VDD.t147 319.627
R492 VDD.t143 VDD.t214 319.627
R493 VDD.t111 VDD.t4 319.627
R494 VDD.t121 VDD.t141 319.627
R495 VDD.t125 VDD.t252 319.627
R496 VDD.t168 VDD.t127 319.627
R497 VDD.n530 VDD.n21 315.303
R498 VDD.n173 VDD.n172 315.303
R499 VDD.n122 VDD.n121 315.303
R500 VDD.n89 VDD.n88 315.303
R501 VDD.n60 VDD.n41 315.303
R502 VDD.n417 VDD.n416 315.303
R503 VDD.n230 VDD.n211 315.303
R504 VDD.n283 VDD.n282 315.303
R505 VDD.n254 VDD.n235 315.303
R506 VDD.t110 VDD 313.707
R507 VDD.t73 VDD 313.707
R508 VDD.t211 VDD 313.707
R509 VDD.t153 VDD 313.707
R510 VDD.t245 VDD 313.707
R511 VDD.t134 VDD 313.707
R512 VDD.t209 VDD.t152 313.707
R513 VDD.t249 VDD 313.707
R514 VDD.t175 VDD 313.707
R515 VDD.t220 VDD 313.707
R516 VDD.t178 VDD 313.707
R517 VDD.t247 VDD.t172 313.707
R518 VDD.t229 VDD 313.707
R519 VDD.t223 VDD 313.707
R520 VDD.t254 VDD 313.707
R521 VDD.t213 VDD 313.707
R522 VDD.t227 VDD.t222 313.707
R523 VDD.t262 VDD 313.707
R524 VDD.t239 VDD 313.707
R525 VDD.t234 VDD 313.707
R526 VDD.t251 VDD 313.707
R527 VDD.t260 VDD.t236 313.707
R528 VDD.n565 VDD.n5 310.502
R529 VDD.t48 VDD.t71 307.788
R530 VDD.t193 VDD.t39 304.829
R531 VDD.t191 VDD.t14 304.829
R532 VDD.t201 VDD.t95 304.829
R533 VDD.t187 VDD.t54 304.829
R534 VDD.t189 VDD.t11 304.829
R535 VDD.t205 VDD.t6 304.829
R536 VDD.t25 VDD 298.911
R537 VDD.t52 VDD 298.911
R538 VDD.t37 VDD 298.911
R539 VDD.t35 VDD 298.911
R540 VDD.t21 VDD 298.911
R541 VDD.t84 VDD 298.911
R542 VDD.t91 VDD 298.911
R543 VDD.t82 VDD 298.911
R544 VDD.t9 VDD 298.911
R545 VDD.t145 VDD 298.911
R546 VDD.t159 VDD 298.911
R547 VDD.t117 VDD 298.911
R548 VDD.t181 VDD 298.911
R549 VDD.t129 VDD 298.911
R550 VDD.t71 VDD.t23 295.95
R551 VDD.t63 VDD.t69 287.072
R552 VDD.t31 VDD.t33 287.072
R553 VDD.t17 VDD.t155 287.072
R554 VDD.t0 VDD.t89 287.072
R555 VDD.t77 VDD.t173 287.072
R556 VDD.t161 VDD.t113 287.072
R557 VDD.t108 VDD.t225 287.072
R558 VDD.t123 VDD.t131 287.072
R559 VDD.t170 VDD.t237 287.072
R560 VDD.t106 VDD.t185 284.113
R561 VDD.t103 VDD.t183 284.113
R562 VDD.t93 VDD.t203 284.113
R563 VDD.t119 VDD.t197 284.113
R564 VDD.t166 VDD.t195 284.113
R565 VDD.t199 VDD.t207 284.113
R566 VDD.t137 VDD.t59 281.154
R567 VDD.t59 VDD.t75 275.235
R568 VDD.n550 VDD.t74 255.905
R569 VDD.n543 VDD.t47 255.905
R570 VDD.n153 VDD.t246 255.905
R571 VDD.n192 VDD.t154 255.905
R572 VDD.n69 VDD.t221 255.905
R573 VDD.n108 VDD.t176 255.905
R574 VDD.n397 VDD.t255 255.905
R575 VDD.n436 VDD.t224 255.905
R576 VDD.n263 VDD.t235 255.905
R577 VDD.n302 VDD.t240 255.905
R578 VDD.t42 VDD.t48 254.518
R579 VDD.n7 VDD.t51 249.363
R580 VDD.t139 VDD.t25 248.599
R581 VDD.t67 VDD.t52 248.599
R582 VDD.t75 VDD.t27 248.599
R583 VDD.t50 VDD.t44 248.599
R584 VDD.t55 VDD.t37 248.599
R585 VDD.t135 VDD.t35 248.599
R586 VDD.t40 VDD.t21 248.599
R587 VDD.t241 VDD.t209 248.599
R588 VDD.t87 VDD.t84 248.599
R589 VDD.t179 VDD.t91 248.599
R590 VDD.t80 VDD.t82 248.599
R591 VDD.t218 VDD.t247 248.599
R592 VDD.t147 VDD.t9 248.599
R593 VDD.t214 VDD.t145 248.599
R594 VDD.t4 VDD.t159 248.599
R595 VDD.t256 VDD.t227 248.599
R596 VDD.t141 VDD.t117 248.599
R597 VDD.t252 VDD.t181 248.599
R598 VDD.t127 VDD.t129 248.599
R599 VDD.t230 VDD.t260 248.599
R600 VDD.n563 VDD.t45 247.394
R601 VDD.n167 VDD.t244 243.512
R602 VDD.n83 VDD.t217 243.512
R603 VDD.n411 VDD.t259 243.512
R604 VDD.n277 VDD.t233 243.512
R605 VDD.t152 VDD.t133 242.679
R606 VDD.t172 VDD.t177 242.679
R607 VDD.t222 VDD.t212 242.679
R608 VDD.t236 VDD.t250 242.679
R609 VDD.n480 VDD.n475 235.248
R610 VDD.n468 VDD.n467 235.248
R611 VDD.n510 VDD.n461 235.248
R612 VDD.n341 VDD.n340 235.248
R613 VDD.n361 VDD.n334 235.248
R614 VDD.n375 VDD.n327 235.248
R615 VDD.t69 VDD.t110 213.084
R616 VDD VDD.t46 213.084
R617 VDD.t33 VDD.t211 213.084
R618 VDD.t155 VDD.t134 213.084
R619 VDD.t243 VDD.t210 213.084
R620 VDD.t89 VDD.t249 213.084
R621 VDD.t173 VDD.t178 213.084
R622 VDD.t216 VDD.t248 213.084
R623 VDD.t79 VDD.t106 213.084
R624 VDD.t105 VDD.t103 213.084
R625 VDD.t96 VDD.t93 213.084
R626 VDD.t113 VDD.t229 213.084
R627 VDD.t225 VDD.t213 213.084
R628 VDD.t258 VDD.t228 213.084
R629 VDD.t86 VDD.t119 213.084
R630 VDD.t165 VDD.t166 213.084
R631 VDD.t149 VDD.t199 213.084
R632 VDD.t131 VDD.t262 213.084
R633 VDD.t237 VDD.t251 213.084
R634 VDD.t232 VDD.t261 213.084
R635 VDD.t44 VDD 207.166
R636 VDD.t27 VDD 192.369
R637 VDD.t23 VDD 192.369
R638 VDD.t133 VDD 192.369
R639 VDD.t177 VDD 192.369
R640 VDD.t212 VDD 192.369
R641 VDD.t250 VDD 192.369
R642 VDD.t210 VDD 189.409
R643 VDD.t248 VDD 189.409
R644 VDD.t228 VDD 189.409
R645 VDD.t261 VDD 189.409
R646 VDD.n475 VDD.t202 123.507
R647 VDD.n467 VDD.t192 123.507
R648 VDD.n461 VDD.t194 123.507
R649 VDD.n340 VDD.t206 123.507
R650 VDD.n334 VDD.t190 123.507
R651 VDD.n327 VDD.t188 123.507
R652 VDD.n5 VDD.t43 117.451
R653 VDD.n17 VDD.t68 116.341
R654 VDD.n24 VDD.t140 116.341
R655 VDD.n156 VDD.t41 116.341
R656 VDD.n120 VDD.t136 116.341
R657 VDD.n126 VDD.t56 116.341
R658 VDD.n72 VDD.t81 116.341
R659 VDD.n64 VDD.t180 116.341
R660 VDD.n44 VDD.t88 116.341
R661 VDD.n400 VDD.t5 116.341
R662 VDD.n208 VDD.t215 116.341
R663 VDD.n214 VDD.t148 116.341
R664 VDD.n266 VDD.t128 116.341
R665 VDD.n258 VDD.t253 116.341
R666 VDD.n238 VDD.t142 116.341
R667 VDD.n21 VDD.t70 96.1553
R668 VDD.n172 VDD.t156 96.1553
R669 VDD.n121 VDD.t34 96.1553
R670 VDD.n88 VDD.t174 96.1553
R671 VDD.n41 VDD.t90 96.1553
R672 VDD.n416 VDD.t226 96.1553
R673 VDD.n211 VDD.t114 96.1553
R674 VDD.n282 VDD.t238 96.1553
R675 VDD.n235 VDD.t132 96.1553
R676 VDD.n11 VDD.t60 93.81
R677 VDD.n2 VDD.t49 86.7743
R678 VDD.n2 VDD.t72 86.7743
R679 VDD.n471 VDD.t94 86.7743
R680 VDD.n464 VDD.t104 86.7743
R681 VDD.n452 VDD.t107 86.7743
R682 VDD.n337 VDD.t200 86.7743
R683 VDD.n330 VDD.t167 86.7743
R684 VDD.n321 VDD.t120 86.7743
R685 VDD.n471 VDD.t204 68.0124
R686 VDD.n464 VDD.t184 68.0124
R687 VDD.n452 VDD.t186 68.0124
R688 VDD.n337 VDD.t208 68.0124
R689 VDD.n330 VDD.t196 68.0124
R690 VDD.n321 VDD.t198 68.0124
R691 VDD.n9 VDD.t76 63.3219
R692 VDD.n9 VDD.t28 63.3219
R693 VDD VDD.t97 59.1905
R694 VDD VDD.t99 59.1905
R695 VDD VDD.t101 59.1905
R696 VDD VDD.t150 59.1905
R697 VDD VDD.t115 59.1905
R698 VDD VDD.t163 59.1905
R699 VDD.n5 VDD.t58 42.3555
R700 VDD.n569 VDD.n3 34.6358
R701 VDD.n558 VDD.n557 34.6358
R702 VDD.n555 VDD.n12 34.6358
R703 VDD.n548 VDD.n14 34.6358
R704 VDD.n549 VDD.n548 34.6358
R705 VDD.n551 VDD.n549 34.6358
R706 VDD.n544 VDD.n542 34.6358
R707 VDD.n539 VDD.n538 34.6358
R708 VDD.n532 VDD.n531 34.6358
R709 VDD.n532 VDD.n18 34.6358
R710 VDD.n536 VDD.n18 34.6358
R711 VDD.n35 VDD.n22 34.6358
R712 VDD.n529 VDD.n22 34.6358
R713 VDD.n33 VDD.n32 34.6358
R714 VDD.n29 VDD.n28 34.6358
R715 VDD.n166 VDD.n165 34.6358
R716 VDD.n171 VDD.n160 34.6358
R717 VDD.n178 VDD.n158 34.6358
R718 VDD.n174 VDD.n158 34.6358
R719 VDD.n181 VDD.n180 34.6358
R720 VDD.n186 VDD.n185 34.6358
R721 VDD.n185 VDD.n154 34.6358
R722 VDD.n191 VDD.n190 34.6358
R723 VDD.n190 VDD.n152 34.6358
R724 VDD.n197 VDD.n150 34.6358
R725 VDD.n193 VDD.n150 34.6358
R726 VDD.n200 VDD.n199 34.6358
R727 VDD.n144 VDD.n143 34.6358
R728 VDD.n147 VDD.n144 34.6358
R729 VDD.n148 VDD.n147 34.6358
R730 VDD.n138 VDD.n137 34.6358
R731 VDD.n139 VDD.n138 34.6358
R732 VDD.n134 VDD.n133 34.6358
R733 VDD.n131 VDD.n127 34.6358
R734 VDD.n82 VDD.n81 34.6358
R735 VDD.n87 VDD.n76 34.6358
R736 VDD.n94 VDD.n74 34.6358
R737 VDD.n90 VDD.n74 34.6358
R738 VDD.n97 VDD.n96 34.6358
R739 VDD.n102 VDD.n101 34.6358
R740 VDD.n101 VDD.n70 34.6358
R741 VDD.n107 VDD.n106 34.6358
R742 VDD.n106 VDD.n68 34.6358
R743 VDD.n113 VDD.n66 34.6358
R744 VDD.n109 VDD.n66 34.6358
R745 VDD.n116 VDD.n115 34.6358
R746 VDD.n521 VDD.n61 34.6358
R747 VDD.n521 VDD.n520 34.6358
R748 VDD.n520 VDD.n62 34.6358
R749 VDD.n55 VDD.n42 34.6358
R750 VDD.n59 VDD.n42 34.6358
R751 VDD.n53 VDD.n52 34.6358
R752 VDD.n49 VDD.n48 34.6358
R753 VDD.n454 VDD.n450 34.6358
R754 VDD.n459 VDD.n450 34.6358
R755 VDD.n460 VDD.n459 34.6358
R756 VDD.n512 VDD.n460 34.6358
R757 VDD.n512 VDD.n511 34.6358
R758 VDD.n509 VDD.n462 34.6358
R759 VDD.n505 VDD.n462 34.6358
R760 VDD.n503 VDD.n502 34.6358
R761 VDD.n502 VDD.n465 34.6358
R762 VDD.n498 VDD.n465 34.6358
R763 VDD.n498 VDD.n497 34.6358
R764 VDD.n497 VDD.n496 34.6358
R765 VDD.n493 VDD.n492 34.6358
R766 VDD.n492 VDD.n469 34.6358
R767 VDD.n488 VDD.n487 34.6358
R768 VDD.n487 VDD.n486 34.6358
R769 VDD.n486 VDD.n473 34.6358
R770 VDD.n482 VDD.n473 34.6358
R771 VDD.n482 VDD.n481 34.6358
R772 VDD.n410 VDD.n409 34.6358
R773 VDD.n415 VDD.n404 34.6358
R774 VDD.n422 VDD.n402 34.6358
R775 VDD.n418 VDD.n402 34.6358
R776 VDD.n425 VDD.n424 34.6358
R777 VDD.n430 VDD.n429 34.6358
R778 VDD.n429 VDD.n398 34.6358
R779 VDD.n435 VDD.n434 34.6358
R780 VDD.n434 VDD.n396 34.6358
R781 VDD.n441 VDD.n394 34.6358
R782 VDD.n437 VDD.n394 34.6358
R783 VDD.n444 VDD.n443 34.6358
R784 VDD.n231 VDD.n209 34.6358
R785 VDD.n391 VDD.n209 34.6358
R786 VDD.n392 VDD.n391 34.6358
R787 VDD.n225 VDD.n212 34.6358
R788 VDD.n229 VDD.n212 34.6358
R789 VDD.n223 VDD.n222 34.6358
R790 VDD.n219 VDD.n218 34.6358
R791 VDD.n383 VDD.n324 34.6358
R792 VDD.n383 VDD.n382 34.6358
R793 VDD.n382 VDD.n381 34.6358
R794 VDD.n381 VDD.n325 34.6358
R795 VDD.n376 VDD.n325 34.6358
R796 VDD.n374 VDD.n373 34.6358
R797 VDD.n373 VDD.n328 34.6358
R798 VDD.n369 VDD.n368 34.6358
R799 VDD.n368 VDD.n367 34.6358
R800 VDD.n367 VDD.n332 34.6358
R801 VDD.n363 VDD.n332 34.6358
R802 VDD.n363 VDD.n362 34.6358
R803 VDD.n360 VDD.n335 34.6358
R804 VDD.n356 VDD.n335 34.6358
R805 VDD.n354 VDD.n353 34.6358
R806 VDD.n353 VDD.n338 34.6358
R807 VDD.n349 VDD.n338 34.6358
R808 VDD.n349 VDD.n348 34.6358
R809 VDD.n348 VDD.n347 34.6358
R810 VDD.n276 VDD.n275 34.6358
R811 VDD.n281 VDD.n270 34.6358
R812 VDD.n288 VDD.n268 34.6358
R813 VDD.n284 VDD.n268 34.6358
R814 VDD.n291 VDD.n290 34.6358
R815 VDD.n296 VDD.n295 34.6358
R816 VDD.n295 VDD.n264 34.6358
R817 VDD.n301 VDD.n300 34.6358
R818 VDD.n300 VDD.n262 34.6358
R819 VDD.n307 VDD.n260 34.6358
R820 VDD.n303 VDD.n260 34.6358
R821 VDD.n310 VDD.n309 34.6358
R822 VDD.n316 VDD.n255 34.6358
R823 VDD.n316 VDD.n315 34.6358
R824 VDD.n315 VDD.n256 34.6358
R825 VDD.n249 VDD.n236 34.6358
R826 VDD.n253 VDD.n236 34.6358
R827 VDD.n247 VDD.n246 34.6358
R828 VDD.n243 VDD.n242 34.6358
R829 VDD.n531 VDD.n530 34.2593
R830 VDD.n173 VDD.n171 34.2593
R831 VDD.n143 VDD.n122 34.2593
R832 VDD.n89 VDD.n87 34.2593
R833 VDD.n61 VDD.n60 34.2593
R834 VDD.n417 VDD.n415 34.2593
R835 VDD.n231 VDD.n230 34.2593
R836 VDD.n283 VDD.n281 34.2593
R837 VDD.n255 VDD.n254 34.2593
R838 VDD.n510 VDD.n509 33.8829
R839 VDD.n493 VDD.n468 33.8829
R840 VDD.n480 VDD.n479 33.8829
R841 VDD.n375 VDD.n374 33.8829
R842 VDD.n361 VDD.n360 33.8829
R843 VDD.n344 VDD.n341 33.8829
R844 VDD.n475 VDD.t102 28.752
R845 VDD.n467 VDD.t100 28.752
R846 VDD.n461 VDD.t98 28.752
R847 VDD.n340 VDD.t164 28.752
R848 VDD.n334 VDD.t116 28.752
R849 VDD.n327 VDD.t151 28.752
R850 VDD.n17 VDD.t66 28.4453
R851 VDD.n24 VDD.t62 28.4453
R852 VDD.n156 VDD.t16 28.4453
R853 VDD.n120 VDD.t20 28.4453
R854 VDD.n126 VDD.t30 28.4453
R855 VDD.n72 VDD.t158 28.4453
R856 VDD.n64 VDD.t13 28.4453
R857 VDD.n44 VDD.t8 28.4453
R858 VDD.n400 VDD.t112 28.4453
R859 VDD.n208 VDD.t144 28.4453
R860 VDD.n214 VDD.t3 28.4453
R861 VDD.n266 VDD.t169 28.4453
R862 VDD.n258 VDD.t126 28.4453
R863 VDD.n238 VDD.t122 28.4453
R864 VDD.n571 VDD.n570 28.2358
R865 VDD.n565 VDD.n564 27.4829
R866 VDD.n557 VDD.n556 27.4829
R867 VDD.n11 VDD.t138 26.9729
R868 VDD.n562 VDD.n7 25.977
R869 VDD.n21 VDD.t64 25.6105
R870 VDD.n172 VDD.t18 25.6105
R871 VDD.n121 VDD.t32 25.6105
R872 VDD.n88 VDD.t78 25.6105
R873 VDD.n41 VDD.t1 25.6105
R874 VDD.n416 VDD.t109 25.6105
R875 VDD.n211 VDD.t162 25.6105
R876 VDD.n282 VDD.t171 25.6105
R877 VDD.n235 VDD.t124 25.6105
R878 VDD.n453 VDD.n451 24.9772
R879 VDD.n323 VDD.n322 24.9772
R880 VDD.n563 VDD.n562 24.4711
R881 VDD.n167 VDD.n160 24.4711
R882 VDD.n83 VDD.n76 24.4711
R883 VDD.n411 VDD.n404 24.4711
R884 VDD.n277 VDD.n270 24.4711
R885 VDD.n564 VDD.n563 23.7181
R886 VDD.n28 VDD.n27 23.7181
R887 VDD.n165 VDD.n162 23.7181
R888 VDD.n128 VDD.n127 23.7181
R889 VDD.n81 VDD.n78 23.7181
R890 VDD.n48 VDD.n47 23.7181
R891 VDD.n479 VDD.n476 23.7181
R892 VDD.n409 VDD.n406 23.7181
R893 VDD.n218 VDD.n217 23.7181
R894 VDD.n344 VDD.n343 23.7181
R895 VDD.n275 VDD.n272 23.7181
R896 VDD.n242 VDD.n241 23.7181
R897 VDD.n556 VDD.n555 22.5887
R898 VDD.n572 VDD.n571 19.9534
R899 VDD.n167 VDD.n166 19.9534
R900 VDD.n83 VDD.n82 19.9534
R901 VDD.n411 VDD.n410 19.9534
R902 VDD.n277 VDD.n276 19.9534
R903 VDD.n454 VDD.n453 17.3181
R904 VDD.n505 VDD.n504 17.3181
R905 VDD.n504 VDD.n503 17.3181
R906 VDD.n472 VDD.n469 17.3181
R907 VDD.n488 VDD.n472 17.3181
R908 VDD.n324 VDD.n323 17.3181
R909 VDD.n331 VDD.n328 17.3181
R910 VDD.n369 VDD.n331 17.3181
R911 VDD.n356 VDD.n355 17.3181
R912 VDD.n355 VDD.n354 17.3181
R913 VDD.n565 VDD.n3 16.9417
R914 VDD.n570 VDD.n569 16.1887
R915 VDD.n558 VDD.n7 12.8005
R916 VDD.n543 VDD.n14 10.5417
R917 VDD.n551 VDD.n550 10.5417
R918 VDD.n153 VDD.n152 10.5417
R919 VDD.n193 VDD.n192 10.5417
R920 VDD.n69 VDD.n68 10.5417
R921 VDD.n109 VDD.n108 10.5417
R922 VDD.n397 VDD.n396 10.5417
R923 VDD.n437 VDD.n436 10.5417
R924 VDD.n263 VDD.n262 10.5417
R925 VDD.n303 VDD.n302 10.5417
R926 VDD.n530 VDD.n529 10.1652
R927 VDD.n174 VDD.n173 10.1652
R928 VDD.n139 VDD.n122 10.1652
R929 VDD.n90 VDD.n89 10.1652
R930 VDD.n60 VDD.n59 10.1652
R931 VDD.n418 VDD.n417 10.1652
R932 VDD.n230 VDD.n229 10.1652
R933 VDD.n284 VDD.n283 10.1652
R934 VDD.n254 VDD.n253 10.1652
R935 VDD.n539 VDD.n15 9.41227
R936 VDD.n34 VDD.n33 9.41227
R937 VDD.n180 VDD.n179 9.41227
R938 VDD.n199 VDD.n198 9.41227
R939 VDD.n134 VDD.n124 9.41227
R940 VDD.n96 VDD.n95 9.41227
R941 VDD.n115 VDD.n114 9.41227
R942 VDD.n54 VDD.n53 9.41227
R943 VDD.n424 VDD.n423 9.41227
R944 VDD.n443 VDD.n442 9.41227
R945 VDD.n224 VDD.n223 9.41227
R946 VDD.n290 VDD.n289 9.41227
R947 VDD.n309 VDD.n308 9.41227
R948 VDD.n248 VDD.n247 9.41227
R949 VDD VDD.n128 9.3031
R950 VDD.n47 VDD 9.3031
R951 VDD.n217 VDD 9.3031
R952 VDD.n241 VDD 9.3031
R953 VDD.n27 VDD 9.3031
R954 VDD.n129 VDD.n127 9.3005
R955 VDD.n131 VDD.n130 9.3005
R956 VDD.n133 VDD.n125 9.3005
R957 VDD.n135 VDD.n134 9.3005
R958 VDD.n137 VDD.n136 9.3005
R959 VDD.n138 VDD.n123 9.3005
R960 VDD.n140 VDD.n139 9.3005
R961 VDD.n141 VDD.n122 9.3005
R962 VDD.n143 VDD.n142 9.3005
R963 VDD.n145 VDD.n144 9.3005
R964 VDD.n147 VDD.n146 9.3005
R965 VDD.n148 VDD.n118 9.3005
R966 VDD.n201 VDD.n200 9.3005
R967 VDD.n199 VDD.n119 9.3005
R968 VDD.n197 VDD.n196 9.3005
R969 VDD.n195 VDD.n150 9.3005
R970 VDD.n194 VDD.n193 9.3005
R971 VDD.n191 VDD.n151 9.3005
R972 VDD.n190 VDD.n189 9.3005
R973 VDD.n188 VDD.n152 9.3005
R974 VDD.n187 VDD.n186 9.3005
R975 VDD.n185 VDD.n184 9.3005
R976 VDD.n183 VDD.n154 9.3005
R977 VDD.n182 VDD.n181 9.3005
R978 VDD.n180 VDD.n155 9.3005
R979 VDD.n178 VDD.n177 9.3005
R980 VDD.n176 VDD.n158 9.3005
R981 VDD.n175 VDD.n174 9.3005
R982 VDD.n173 VDD.n159 9.3005
R983 VDD.n171 VDD.n170 9.3005
R984 VDD.n169 VDD.n160 9.3005
R985 VDD.n168 VDD.n167 9.3005
R986 VDD.n166 VDD.n161 9.3005
R987 VDD.n165 VDD.n164 9.3005
R988 VDD.n48 VDD.n46 9.3005
R989 VDD.n50 VDD.n49 9.3005
R990 VDD.n52 VDD.n51 9.3005
R991 VDD.n53 VDD.n43 9.3005
R992 VDD.n56 VDD.n55 9.3005
R993 VDD.n57 VDD.n42 9.3005
R994 VDD.n59 VDD.n58 9.3005
R995 VDD.n60 VDD.n40 9.3005
R996 VDD.n61 VDD.n39 9.3005
R997 VDD.n522 VDD.n521 9.3005
R998 VDD.n520 VDD.n519 9.3005
R999 VDD.n518 VDD.n62 9.3005
R1000 VDD.n117 VDD.n116 9.3005
R1001 VDD.n115 VDD.n63 9.3005
R1002 VDD.n113 VDD.n112 9.3005
R1003 VDD.n111 VDD.n66 9.3005
R1004 VDD.n110 VDD.n109 9.3005
R1005 VDD.n107 VDD.n67 9.3005
R1006 VDD.n106 VDD.n105 9.3005
R1007 VDD.n104 VDD.n68 9.3005
R1008 VDD.n103 VDD.n102 9.3005
R1009 VDD.n101 VDD.n100 9.3005
R1010 VDD.n99 VDD.n70 9.3005
R1011 VDD.n98 VDD.n97 9.3005
R1012 VDD.n96 VDD.n71 9.3005
R1013 VDD.n94 VDD.n93 9.3005
R1014 VDD.n92 VDD.n74 9.3005
R1015 VDD.n91 VDD.n90 9.3005
R1016 VDD.n89 VDD.n75 9.3005
R1017 VDD.n87 VDD.n86 9.3005
R1018 VDD.n85 VDD.n76 9.3005
R1019 VDD.n84 VDD.n83 9.3005
R1020 VDD.n82 VDD.n77 9.3005
R1021 VDD.n81 VDD.n80 9.3005
R1022 VDD.n455 VDD.n454 9.3005
R1023 VDD.n457 VDD.n450 9.3005
R1024 VDD.n459 VDD.n458 9.3005
R1025 VDD.n460 VDD.n448 9.3005
R1026 VDD.n513 VDD.n512 9.3005
R1027 VDD.n511 VDD.n449 9.3005
R1028 VDD.n509 VDD.n508 9.3005
R1029 VDD.n507 VDD.n462 9.3005
R1030 VDD.n506 VDD.n505 9.3005
R1031 VDD.n503 VDD.n463 9.3005
R1032 VDD.n502 VDD.n501 9.3005
R1033 VDD.n500 VDD.n465 9.3005
R1034 VDD.n499 VDD.n498 9.3005
R1035 VDD.n497 VDD.n466 9.3005
R1036 VDD.n496 VDD.n495 9.3005
R1037 VDD.n494 VDD.n493 9.3005
R1038 VDD.n492 VDD.n491 9.3005
R1039 VDD.n490 VDD.n469 9.3005
R1040 VDD.n489 VDD.n488 9.3005
R1041 VDD.n487 VDD.n470 9.3005
R1042 VDD.n486 VDD.n485 9.3005
R1043 VDD.n484 VDD.n473 9.3005
R1044 VDD.n483 VDD.n482 9.3005
R1045 VDD.n481 VDD.n474 9.3005
R1046 VDD.n479 VDD.n478 9.3005
R1047 VDD.n477 VDD.n476 9.3005
R1048 VDD.n218 VDD.n216 9.3005
R1049 VDD.n220 VDD.n219 9.3005
R1050 VDD.n222 VDD.n221 9.3005
R1051 VDD.n223 VDD.n213 9.3005
R1052 VDD.n226 VDD.n225 9.3005
R1053 VDD.n227 VDD.n212 9.3005
R1054 VDD.n229 VDD.n228 9.3005
R1055 VDD.n230 VDD.n210 9.3005
R1056 VDD.n232 VDD.n231 9.3005
R1057 VDD.n389 VDD.n209 9.3005
R1058 VDD.n391 VDD.n390 9.3005
R1059 VDD.n392 VDD.n206 9.3005
R1060 VDD.n445 VDD.n444 9.3005
R1061 VDD.n443 VDD.n207 9.3005
R1062 VDD.n441 VDD.n440 9.3005
R1063 VDD.n439 VDD.n394 9.3005
R1064 VDD.n438 VDD.n437 9.3005
R1065 VDD.n435 VDD.n395 9.3005
R1066 VDD.n434 VDD.n433 9.3005
R1067 VDD.n432 VDD.n396 9.3005
R1068 VDD.n431 VDD.n430 9.3005
R1069 VDD.n429 VDD.n428 9.3005
R1070 VDD.n427 VDD.n398 9.3005
R1071 VDD.n426 VDD.n425 9.3005
R1072 VDD.n424 VDD.n399 9.3005
R1073 VDD.n422 VDD.n421 9.3005
R1074 VDD.n420 VDD.n402 9.3005
R1075 VDD.n419 VDD.n418 9.3005
R1076 VDD.n417 VDD.n403 9.3005
R1077 VDD.n415 VDD.n414 9.3005
R1078 VDD.n413 VDD.n404 9.3005
R1079 VDD.n412 VDD.n411 9.3005
R1080 VDD.n410 VDD.n405 9.3005
R1081 VDD.n409 VDD.n408 9.3005
R1082 VDD.n324 VDD.n319 9.3005
R1083 VDD.n384 VDD.n383 9.3005
R1084 VDD.n382 VDD.n320 9.3005
R1085 VDD.n381 VDD.n380 9.3005
R1086 VDD.n378 VDD.n325 9.3005
R1087 VDD.n377 VDD.n376 9.3005
R1088 VDD.n374 VDD.n326 9.3005
R1089 VDD.n373 VDD.n372 9.3005
R1090 VDD.n371 VDD.n328 9.3005
R1091 VDD.n370 VDD.n369 9.3005
R1092 VDD.n368 VDD.n329 9.3005
R1093 VDD.n367 VDD.n366 9.3005
R1094 VDD.n365 VDD.n332 9.3005
R1095 VDD.n364 VDD.n363 9.3005
R1096 VDD.n362 VDD.n333 9.3005
R1097 VDD.n360 VDD.n359 9.3005
R1098 VDD.n358 VDD.n335 9.3005
R1099 VDD.n357 VDD.n356 9.3005
R1100 VDD.n354 VDD.n336 9.3005
R1101 VDD.n353 VDD.n352 9.3005
R1102 VDD.n351 VDD.n338 9.3005
R1103 VDD.n350 VDD.n349 9.3005
R1104 VDD.n348 VDD.n339 9.3005
R1105 VDD.n347 VDD.n346 9.3005
R1106 VDD.n345 VDD.n344 9.3005
R1107 VDD.n343 VDD.n342 9.3005
R1108 VDD.n242 VDD.n240 9.3005
R1109 VDD.n244 VDD.n243 9.3005
R1110 VDD.n246 VDD.n245 9.3005
R1111 VDD.n247 VDD.n237 9.3005
R1112 VDD.n250 VDD.n249 9.3005
R1113 VDD.n251 VDD.n236 9.3005
R1114 VDD.n253 VDD.n252 9.3005
R1115 VDD.n254 VDD.n234 9.3005
R1116 VDD.n255 VDD.n233 9.3005
R1117 VDD.n317 VDD.n316 9.3005
R1118 VDD.n315 VDD.n314 9.3005
R1119 VDD.n313 VDD.n256 9.3005
R1120 VDD.n311 VDD.n310 9.3005
R1121 VDD.n309 VDD.n257 9.3005
R1122 VDD.n307 VDD.n306 9.3005
R1123 VDD.n305 VDD.n260 9.3005
R1124 VDD.n304 VDD.n303 9.3005
R1125 VDD.n301 VDD.n261 9.3005
R1126 VDD.n300 VDD.n299 9.3005
R1127 VDD.n298 VDD.n262 9.3005
R1128 VDD.n297 VDD.n296 9.3005
R1129 VDD.n295 VDD.n294 9.3005
R1130 VDD.n293 VDD.n264 9.3005
R1131 VDD.n292 VDD.n291 9.3005
R1132 VDD.n290 VDD.n265 9.3005
R1133 VDD.n288 VDD.n287 9.3005
R1134 VDD.n286 VDD.n268 9.3005
R1135 VDD.n285 VDD.n284 9.3005
R1136 VDD.n283 VDD.n269 9.3005
R1137 VDD.n281 VDD.n280 9.3005
R1138 VDD.n279 VDD.n270 9.3005
R1139 VDD.n278 VDD.n277 9.3005
R1140 VDD.n276 VDD.n271 9.3005
R1141 VDD.n275 VDD.n274 9.3005
R1142 VDD.n28 VDD.n26 9.3005
R1143 VDD.n30 VDD.n29 9.3005
R1144 VDD.n32 VDD.n31 9.3005
R1145 VDD.n33 VDD.n23 9.3005
R1146 VDD.n36 VDD.n35 9.3005
R1147 VDD.n527 VDD.n22 9.3005
R1148 VDD.n529 VDD.n528 9.3005
R1149 VDD.n530 VDD.n20 9.3005
R1150 VDD.n531 VDD.n19 9.3005
R1151 VDD.n533 VDD.n532 9.3005
R1152 VDD.n534 VDD.n18 9.3005
R1153 VDD.n536 VDD.n535 9.3005
R1154 VDD.n538 VDD.n16 9.3005
R1155 VDD.n540 VDD.n539 9.3005
R1156 VDD.n542 VDD.n541 9.3005
R1157 VDD.n545 VDD.n544 9.3005
R1158 VDD.n546 VDD.n14 9.3005
R1159 VDD.n548 VDD.n547 9.3005
R1160 VDD.n549 VDD.n13 9.3005
R1161 VDD.n552 VDD.n551 9.3005
R1162 VDD.n553 VDD.n12 9.3005
R1163 VDD.n555 VDD.n554 9.3005
R1164 VDD.n556 VDD.n10 9.3005
R1165 VDD.n557 VDD.n8 9.3005
R1166 VDD.n560 VDD.n7 9.3005
R1167 VDD.n562 VDD.n561 9.3005
R1168 VDD.n563 VDD.n6 9.3005
R1169 VDD.n564 VDD.n4 9.3005
R1170 VDD.n566 VDD.n565 9.3005
R1171 VDD.n567 VDD.n3 9.3005
R1172 VDD.n569 VDD.n568 9.3005
R1173 VDD.n570 VDD.n1 9.3005
R1174 VDD.n571 VDD.n0 9.3005
R1175 VDD.n573 VDD.n572 9.3005
R1176 VDD.n386 VDD.n318 8.51044
R1177 VDD.n312 VDD.n205 8.51044
R1178 VDD.n525 VDD.n37 8.48141
R1179 VDD.n204 VDD.n202 8.48003
R1180 VDD.n550 VDD.n12 8.28285
R1181 VDD.n544 VDD.n543 8.28285
R1182 VDD.n186 VDD.n153 8.28285
R1183 VDD.n192 VDD.n191 8.28285
R1184 VDD.n102 VDD.n69 8.28285
R1185 VDD.n108 VDD.n107 8.28285
R1186 VDD.n430 VDD.n397 8.28285
R1187 VDD.n436 VDD.n435 8.28285
R1188 VDD.n296 VDD.n263 8.28285
R1189 VDD.n302 VDD.n301 8.28285
R1190 VDD.n524 VDD.n523 7.9105
R1191 VDD.n456 VDD.n38 7.9105
R1192 VDD.n388 VDD.n387 7.9105
R1193 VDD.n386 VDD.n385 7.9105
R1194 VDD.n379 VDD.n205 7.9105
R1195 VDD.n447 VDD.n446 7.9105
R1196 VDD.n515 VDD.n514 7.9105
R1197 VDD.n517 VDD.n516 7.9105
R1198 VDD.n204 VDD.n203 7.9105
R1199 VDD.n526 VDD.n525 7.9105
R1200 VDD.n163 VDD.n162 7.25905
R1201 VDD.n79 VDD.n78 7.25905
R1202 VDD.n407 VDD.n406 7.25905
R1203 VDD.n273 VDD.n272 7.25905
R1204 VDD.n538 VDD.n537 6.4005
R1205 VDD.n32 VDD.n25 6.4005
R1206 VDD.n181 VDD.n157 6.4005
R1207 VDD.n200 VDD.n149 6.4005
R1208 VDD.n133 VDD.n132 6.4005
R1209 VDD.n97 VDD.n73 6.4005
R1210 VDD.n116 VDD.n65 6.4005
R1211 VDD.n52 VDD.n45 6.4005
R1212 VDD.n425 VDD.n401 6.4005
R1213 VDD.n444 VDD.n393 6.4005
R1214 VDD.n222 VDD.n215 6.4005
R1215 VDD.n291 VDD.n267 6.4005
R1216 VDD.n310 VDD.n259 6.4005
R1217 VDD.n246 VDD.n239 6.4005
R1218 VDD.n559 VDD.n558 4.62124
R1219 VDD.n542 VDD.n15 4.14168
R1220 VDD.n35 VDD.n34 4.14168
R1221 VDD.n179 VDD.n178 4.14168
R1222 VDD.n198 VDD.n197 4.14168
R1223 VDD.n137 VDD.n124 4.14168
R1224 VDD.n95 VDD.n94 4.14168
R1225 VDD.n114 VDD.n113 4.14168
R1226 VDD.n55 VDD.n54 4.14168
R1227 VDD.n423 VDD.n422 4.14168
R1228 VDD.n442 VDD.n441 4.14168
R1229 VDD.n225 VDD.n224 4.14168
R1230 VDD.n289 VDD.n288 4.14168
R1231 VDD.n308 VDD.n307 4.14168
R1232 VDD.n249 VDD.n248 4.14168
R1233 VDD.n537 VDD.n536 3.38874
R1234 VDD.n29 VDD.n25 3.38874
R1235 VDD.n157 VDD.n154 3.38874
R1236 VDD.n149 VDD.n148 3.38874
R1237 VDD.n132 VDD.n131 3.38874
R1238 VDD.n73 VDD.n70 3.38874
R1239 VDD.n65 VDD.n62 3.38874
R1240 VDD.n49 VDD.n45 3.38874
R1241 VDD.n401 VDD.n398 3.38874
R1242 VDD.n393 VDD.n392 3.38874
R1243 VDD.n219 VDD.n215 3.38874
R1244 VDD.n267 VDD.n264 3.38874
R1245 VDD.n259 VDD.n256 3.38874
R1246 VDD.n243 VDD.n239 3.38874
R1247 VDD.n511 VDD.n510 0.753441
R1248 VDD.n496 VDD.n468 0.753441
R1249 VDD.n481 VDD.n480 0.753441
R1250 VDD.n376 VDD.n375 0.753441
R1251 VDD.n362 VDD.n361 0.753441
R1252 VDD.n347 VDD.n341 0.753441
R1253 VDD.n525 VDD.n524 0.605971
R1254 VDD.n516 VDD.n204 0.605971
R1255 VDD.n387 VDD.n38 0.600441
R1256 VDD.n515 VDD.n447 0.600441
R1257 VDD.n516 VDD.n515 0.576941
R1258 VDD.n524 VDD.n38 0.575559
R1259 VDD.n447 VDD.n205 0.575559
R1260 VDD.n387 VDD.n386 0.574176
R1261 VDD.n163 VDD 0.47207
R1262 VDD.n79 VDD 0.47207
R1263 VDD.n407 VDD 0.47207
R1264 VDD.n273 VDD 0.47207
R1265 VDD.n559 VDD.n8 0.180304
R1266 VDD.n455 VDD.n451 0.141218
R1267 VDD.n322 VDD.n319 0.141218
R1268 VDD.n130 VDD.n129 0.120292
R1269 VDD.n130 VDD.n125 0.120292
R1270 VDD.n135 VDD.n125 0.120292
R1271 VDD.n136 VDD.n135 0.120292
R1272 VDD.n140 VDD.n123 0.120292
R1273 VDD.n141 VDD.n140 0.120292
R1274 VDD.n142 VDD.n141 0.120292
R1275 VDD.n146 VDD.n118 0.120292
R1276 VDD.n201 VDD.n119 0.120292
R1277 VDD.n196 VDD.n119 0.120292
R1278 VDD.n195 VDD.n194 0.120292
R1279 VDD.n194 VDD.n151 0.120292
R1280 VDD.n189 VDD.n188 0.120292
R1281 VDD.n188 VDD.n187 0.120292
R1282 VDD.n184 VDD.n183 0.120292
R1283 VDD.n183 VDD.n182 0.120292
R1284 VDD.n182 VDD.n155 0.120292
R1285 VDD.n177 VDD.n155 0.120292
R1286 VDD.n176 VDD.n175 0.120292
R1287 VDD.n175 VDD.n159 0.120292
R1288 VDD.n170 VDD.n159 0.120292
R1289 VDD.n170 VDD.n169 0.120292
R1290 VDD.n168 VDD.n161 0.120292
R1291 VDD.n164 VDD.n161 0.120292
R1292 VDD.n50 VDD.n46 0.120292
R1293 VDD.n51 VDD.n50 0.120292
R1294 VDD.n51 VDD.n43 0.120292
R1295 VDD.n56 VDD.n43 0.120292
R1296 VDD.n58 VDD.n57 0.120292
R1297 VDD.n58 VDD.n40 0.120292
R1298 VDD.n40 VDD.n39 0.120292
R1299 VDD.n519 VDD.n518 0.120292
R1300 VDD.n117 VDD.n63 0.120292
R1301 VDD.n112 VDD.n63 0.120292
R1302 VDD.n111 VDD.n110 0.120292
R1303 VDD.n110 VDD.n67 0.120292
R1304 VDD.n105 VDD.n104 0.120292
R1305 VDD.n104 VDD.n103 0.120292
R1306 VDD.n100 VDD.n99 0.120292
R1307 VDD.n99 VDD.n98 0.120292
R1308 VDD.n98 VDD.n71 0.120292
R1309 VDD.n93 VDD.n71 0.120292
R1310 VDD.n92 VDD.n91 0.120292
R1311 VDD.n91 VDD.n75 0.120292
R1312 VDD.n86 VDD.n75 0.120292
R1313 VDD.n86 VDD.n85 0.120292
R1314 VDD.n84 VDD.n77 0.120292
R1315 VDD.n80 VDD.n77 0.120292
R1316 VDD.n458 VDD.n457 0.120292
R1317 VDD.n458 VDD.n448 0.120292
R1318 VDD.n513 VDD.n449 0.120292
R1319 VDD.n508 VDD.n449 0.120292
R1320 VDD.n507 VDD.n506 0.120292
R1321 VDD.n506 VDD.n463 0.120292
R1322 VDD.n501 VDD.n463 0.120292
R1323 VDD.n501 VDD.n500 0.120292
R1324 VDD.n500 VDD.n499 0.120292
R1325 VDD.n499 VDD.n466 0.120292
R1326 VDD.n495 VDD.n466 0.120292
R1327 VDD.n495 VDD.n494 0.120292
R1328 VDD.n491 VDD.n490 0.120292
R1329 VDD.n490 VDD.n489 0.120292
R1330 VDD.n489 VDD.n470 0.120292
R1331 VDD.n485 VDD.n470 0.120292
R1332 VDD.n485 VDD.n484 0.120292
R1333 VDD.n484 VDD.n483 0.120292
R1334 VDD.n483 VDD.n474 0.120292
R1335 VDD.n478 VDD.n474 0.120292
R1336 VDD.n220 VDD.n216 0.120292
R1337 VDD.n221 VDD.n220 0.120292
R1338 VDD.n221 VDD.n213 0.120292
R1339 VDD.n226 VDD.n213 0.120292
R1340 VDD.n228 VDD.n227 0.120292
R1341 VDD.n228 VDD.n210 0.120292
R1342 VDD.n232 VDD.n210 0.120292
R1343 VDD.n390 VDD.n206 0.120292
R1344 VDD.n445 VDD.n207 0.120292
R1345 VDD.n440 VDD.n207 0.120292
R1346 VDD.n439 VDD.n438 0.120292
R1347 VDD.n438 VDD.n395 0.120292
R1348 VDD.n433 VDD.n432 0.120292
R1349 VDD.n432 VDD.n431 0.120292
R1350 VDD.n428 VDD.n427 0.120292
R1351 VDD.n427 VDD.n426 0.120292
R1352 VDD.n426 VDD.n399 0.120292
R1353 VDD.n421 VDD.n399 0.120292
R1354 VDD.n420 VDD.n419 0.120292
R1355 VDD.n419 VDD.n403 0.120292
R1356 VDD.n414 VDD.n403 0.120292
R1357 VDD.n414 VDD.n413 0.120292
R1358 VDD.n412 VDD.n405 0.120292
R1359 VDD.n408 VDD.n405 0.120292
R1360 VDD.n384 VDD.n320 0.120292
R1361 VDD.n380 VDD.n320 0.120292
R1362 VDD.n378 VDD.n377 0.120292
R1363 VDD.n377 VDD.n326 0.120292
R1364 VDD.n372 VDD.n371 0.120292
R1365 VDD.n371 VDD.n370 0.120292
R1366 VDD.n370 VDD.n329 0.120292
R1367 VDD.n366 VDD.n329 0.120292
R1368 VDD.n366 VDD.n365 0.120292
R1369 VDD.n365 VDD.n364 0.120292
R1370 VDD.n364 VDD.n333 0.120292
R1371 VDD.n359 VDD.n333 0.120292
R1372 VDD.n358 VDD.n357 0.120292
R1373 VDD.n357 VDD.n336 0.120292
R1374 VDD.n352 VDD.n336 0.120292
R1375 VDD.n352 VDD.n351 0.120292
R1376 VDD.n351 VDD.n350 0.120292
R1377 VDD.n350 VDD.n339 0.120292
R1378 VDD.n346 VDD.n339 0.120292
R1379 VDD.n346 VDD.n345 0.120292
R1380 VDD.n244 VDD.n240 0.120292
R1381 VDD.n245 VDD.n244 0.120292
R1382 VDD.n245 VDD.n237 0.120292
R1383 VDD.n250 VDD.n237 0.120292
R1384 VDD.n252 VDD.n251 0.120292
R1385 VDD.n252 VDD.n234 0.120292
R1386 VDD.n234 VDD.n233 0.120292
R1387 VDD.n314 VDD.n313 0.120292
R1388 VDD.n311 VDD.n257 0.120292
R1389 VDD.n306 VDD.n257 0.120292
R1390 VDD.n305 VDD.n304 0.120292
R1391 VDD.n304 VDD.n261 0.120292
R1392 VDD.n299 VDD.n298 0.120292
R1393 VDD.n298 VDD.n297 0.120292
R1394 VDD.n294 VDD.n293 0.120292
R1395 VDD.n293 VDD.n292 0.120292
R1396 VDD.n292 VDD.n265 0.120292
R1397 VDD.n287 VDD.n265 0.120292
R1398 VDD.n286 VDD.n285 0.120292
R1399 VDD.n285 VDD.n269 0.120292
R1400 VDD.n280 VDD.n269 0.120292
R1401 VDD.n280 VDD.n279 0.120292
R1402 VDD.n278 VDD.n271 0.120292
R1403 VDD.n274 VDD.n271 0.120292
R1404 VDD.n30 VDD.n26 0.120292
R1405 VDD.n31 VDD.n30 0.120292
R1406 VDD.n31 VDD.n23 0.120292
R1407 VDD.n36 VDD.n23 0.120292
R1408 VDD.n528 VDD.n527 0.120292
R1409 VDD.n528 VDD.n20 0.120292
R1410 VDD.n533 VDD.n19 0.120292
R1411 VDD.n535 VDD.n534 0.120292
R1412 VDD.n535 VDD.n16 0.120292
R1413 VDD.n540 VDD.n16 0.120292
R1414 VDD.n541 VDD.n540 0.120292
R1415 VDD.n547 VDD.n546 0.120292
R1416 VDD.n552 VDD.n13 0.120292
R1417 VDD.n553 VDD.n552 0.120292
R1418 VDD.n554 VDD.n10 0.120292
R1419 VDD.n10 VDD.n8 0.120292
R1420 VDD.n561 VDD.n560 0.120292
R1421 VDD.n561 VDD.n6 0.120292
R1422 VDD.n566 VDD.n4 0.120292
R1423 VDD.n567 VDD.n566 0.120292
R1424 VDD.n568 VDD.n567 0.120292
R1425 VDD.n568 VDD.n1 0.120292
R1426 VDD.n1 VDD.n0 0.120292
R1427 VDD.n573 VDD.n0 0.120292
R1428 VDD.n457 VDD.n456 0.112479
R1429 VDD.n385 VDD.n384 0.112479
R1430 VDD.n203 VDD.n20 0.107271
R1431 VDD.n145 VDD.n37 0.102062
R1432 VDD.n523 VDD.n522 0.102062
R1433 VDD.n389 VDD.n388 0.102062
R1434 VDD.n318 VDD.n317 0.102062
R1435 VDD.n546 VDD 0.0981562
R1436 VDD.n451 VDD 0.0975039
R1437 VDD.n322 VDD 0.0975039
R1438 VDD VDD.n163 0.0925638
R1439 VDD VDD.n79 0.0925638
R1440 VDD VDD.n407 0.0925638
R1441 VDD VDD.n273 0.0925638
R1442 VDD VDD.n26 0.0890417
R1443 VDD VDD.n559 0.082648
R1444 VDD.n514 VDD.n513 0.0708125
R1445 VDD.n379 VDD.n378 0.0708125
R1446 VDD.n129 VDD 0.0603958
R1447 VDD VDD.n123 0.0603958
R1448 VDD.n146 VDD 0.0603958
R1449 VDD.n202 VDD.n118 0.0603958
R1450 VDD.n202 VDD.n201 0.0603958
R1451 VDD VDD.n195 0.0603958
R1452 VDD.n189 VDD 0.0603958
R1453 VDD.n184 VDD 0.0603958
R1454 VDD VDD.n176 0.0603958
R1455 VDD VDD.n168 0.0603958
R1456 VDD VDD.n46 0.0603958
R1457 VDD.n57 VDD 0.0603958
R1458 VDD.n519 VDD 0.0603958
R1459 VDD.n518 VDD.n517 0.0603958
R1460 VDD.n517 VDD.n117 0.0603958
R1461 VDD VDD.n111 0.0603958
R1462 VDD.n105 VDD 0.0603958
R1463 VDD.n100 VDD 0.0603958
R1464 VDD VDD.n92 0.0603958
R1465 VDD VDD.n84 0.0603958
R1466 VDD VDD.n507 0.0603958
R1467 VDD.n491 VDD 0.0603958
R1468 VDD VDD.n477 0.0603958
R1469 VDD VDD.n216 0.0603958
R1470 VDD.n227 VDD 0.0603958
R1471 VDD.n390 VDD 0.0603958
R1472 VDD.n446 VDD.n206 0.0603958
R1473 VDD.n446 VDD.n445 0.0603958
R1474 VDD VDD.n439 0.0603958
R1475 VDD.n433 VDD 0.0603958
R1476 VDD.n428 VDD 0.0603958
R1477 VDD VDD.n420 0.0603958
R1478 VDD VDD.n412 0.0603958
R1479 VDD.n372 VDD 0.0603958
R1480 VDD VDD.n358 0.0603958
R1481 VDD.n342 VDD 0.0603958
R1482 VDD VDD.n240 0.0603958
R1483 VDD.n251 VDD 0.0603958
R1484 VDD.n314 VDD 0.0603958
R1485 VDD.n313 VDD.n312 0.0603958
R1486 VDD.n312 VDD.n311 0.0603958
R1487 VDD VDD.n305 0.0603958
R1488 VDD.n299 VDD 0.0603958
R1489 VDD.n294 VDD 0.0603958
R1490 VDD VDD.n286 0.0603958
R1491 VDD VDD.n278 0.0603958
R1492 VDD.n534 VDD 0.0603958
R1493 VDD.n545 VDD 0.0603958
R1494 VDD.n547 VDD 0.0603958
R1495 VDD VDD.n13 0.0603958
R1496 VDD.n554 VDD 0.0603958
R1497 VDD.n560 VDD 0.0603958
R1498 VDD VDD.n4 0.0603958
R1499 VDD.n527 VDD.n526 0.0551875
R1500 VDD.n514 VDD.n448 0.0499792
R1501 VDD.n380 VDD.n379 0.0499792
R1502 VDD.n477 VDD 0.03175
R1503 VDD.n342 VDD 0.03175
R1504 VDD.n6 VDD 0.0239375
R1505 VDD.n136 VDD 0.0226354
R1506 VDD VDD.n145 0.0226354
R1507 VDD.n196 VDD 0.0226354
R1508 VDD VDD.n151 0.0226354
R1509 VDD.n187 VDD 0.0226354
R1510 VDD.n177 VDD 0.0226354
R1511 VDD.n169 VDD 0.0226354
R1512 VDD VDD.n56 0.0226354
R1513 VDD.n522 VDD 0.0226354
R1514 VDD.n112 VDD 0.0226354
R1515 VDD VDD.n67 0.0226354
R1516 VDD.n103 VDD 0.0226354
R1517 VDD.n93 VDD 0.0226354
R1518 VDD.n85 VDD 0.0226354
R1519 VDD VDD.n226 0.0226354
R1520 VDD VDD.n389 0.0226354
R1521 VDD.n440 VDD 0.0226354
R1522 VDD VDD.n395 0.0226354
R1523 VDD.n431 VDD 0.0226354
R1524 VDD.n421 VDD 0.0226354
R1525 VDD.n413 VDD 0.0226354
R1526 VDD VDD.n250 0.0226354
R1527 VDD.n317 VDD 0.0226354
R1528 VDD.n306 VDD 0.0226354
R1529 VDD VDD.n261 0.0226354
R1530 VDD.n297 VDD 0.0226354
R1531 VDD.n287 VDD 0.0226354
R1532 VDD.n279 VDD 0.0226354
R1533 VDD VDD.n36 0.0226354
R1534 VDD VDD.n533 0.0226354
R1535 VDD.n541 VDD 0.0226354
R1536 VDD VDD.n545 0.0226354
R1537 VDD VDD.n553 0.0226354
R1538 VDD VDD.n573 0.0226354
R1539 VDD.n164 VDD 0.0213333
R1540 VDD.n80 VDD 0.0213333
R1541 VDD.n508 VDD 0.0213333
R1542 VDD.n494 VDD 0.0213333
R1543 VDD.n478 VDD 0.0213333
R1544 VDD.n408 VDD 0.0213333
R1545 VDD VDD.n326 0.0213333
R1546 VDD.n359 VDD 0.0213333
R1547 VDD.n345 VDD 0.0213333
R1548 VDD.n274 VDD 0.0213333
R1549 VDD.n142 VDD.n37 0.0187292
R1550 VDD.n523 VDD.n39 0.0187292
R1551 VDD.n388 VDD.n232 0.0187292
R1552 VDD.n318 VDD.n233 0.0187292
R1553 VDD.n203 VDD.n19 0.0135208
R1554 VDD.n456 VDD.n455 0.0083125
R1555 VDD.n385 VDD.n319 0.0083125
R1556 VDD.n526 VDD 0.00570833
R1557 GND.n560 GND.n461 1.66247e+06
R1558 GND GND.n161 8265.36
R1559 GND.n561 GND.n560 7459.17
R1560 GND.n432 GND.n162 7429.45
R1561 GND.n562 GND.n161 5474.42
R1562 GND.n562 GND.n561 5474.42
R1563 GND.n461 GND.n460 4203.57
R1564 GND.n460 GND.n432 4203.57
R1565 GND GND.t108 2634.3
R1566 GND GND.t155 2634.3
R1567 GND.n162 GND.t106 2620.06
R1568 GND GND.t236 2420.71
R1569 GND GND.t228 2420.71
R1570 GND GND.t110 2377.99
R1571 GND GND.t153 2377.99
R1572 GND.t35 GND.t63 2227.65
R1573 GND GND.t230 1808.41
R1574 GND GND.t182 1801.83
R1575 GND GND.t194 1801.83
R1576 GND GND.t170 1801.83
R1577 GND GND.t190 1801.83
R1578 GND GND.t226 1765.7
R1579 GND.n560 GND 1721.36
R1580 GND.t26 GND 1624.75
R1581 GND.t16 GND 1624.75
R1582 GND.t93 GND 1592.95
R1583 GND GND.t65 1592.95
R1584 GND.t106 GND.t127 1537.86
R1585 GND.t110 GND.t252 1537.86
R1586 GND.t153 GND.t112 1537.86
R1587 GND.t236 GND 1509.39
R1588 GND.t228 GND 1509.39
R1589 GND.t141 GND 1493.01
R1590 GND.t242 GND 1493.01
R1591 GND.t232 GND.t250 1466.67
R1592 GND.t18 GND 1466.67
R1593 GND.t14 GND 1466.67
R1594 GND.t218 GND 1463.8
R1595 GND.t256 GND 1463.8
R1596 GND GND.t161 1463.8
R1597 GND GND.t212 1463.8
R1598 GND GND.t53 1461.4
R1599 GND.n558 GND.t51 1453.5
R1600 GND.t103 GND 1438.19
R1601 GND.t169 GND 1438.19
R1602 GND.t114 GND 1438.19
R1603 GND.t129 GND 1437.96
R1604 GND.t97 GND 1437.96
R1605 GND GND.t11 1437.96
R1606 GND GND.t143 1437.96
R1607 GND.n198 GND.t184 1431.81
R1608 GND.n433 GND.t172 1431.81
R1609 GND.t108 GND.t115 1381.23
R1610 GND.t155 GND.t234 1381.23
R1611 GND.t184 GND.t104 1351.37
R1612 GND.t182 GND.t151 1351.37
R1613 GND.t194 GND.t186 1351.37
R1614 GND.t172 GND.t91 1351.37
R1615 GND.t170 GND.t88 1351.37
R1616 GND.t190 GND.t78 1351.37
R1617 GND.t266 GND 1338.51
R1618 GND.t254 GND 1338.51
R1619 GND GND.t55 1319.21
R1620 GND.t47 GND.t39 1311.31
R1621 GND.t262 GND.t232 1210.36
R1622 GND.n459 GND.n458 1198.25
R1623 GND.n565 GND.n564 1198.25
R1624 GND.n201 GND.n200 1198.25
R1625 GND.n431 GND.n430 1198.25
R1626 GND.n249 GND.n162 1198.25
R1627 GND.n557 GND.n556 1198.25
R1628 GND.n558 GND.n0 1198.25
R1629 GND.t127 GND.t103 1196.12
R1630 GND.t115 GND.t266 1196.12
R1631 GND.t252 GND.t169 1196.12
R1632 GND.t112 GND.t114 1196.12
R1633 GND.t234 GND.t254 1196.12
R1634 GND.t230 GND.t264 1196.12
R1635 GND.t226 GND.t262 1196.12
R1636 GND.t238 GND 1115.37
R1637 GND.n561 GND 1105.92
R1638 GND.t260 GND 1093.54
R1639 GND GND.t210 1093.54
R1640 GND.t240 GND 1089.02
R1641 GND.n200 GND 1045.7
R1642 GND.n564 GND 1045.7
R1643 GND.t123 GND.t49 1011.13
R1644 GND.t44 GND.t72 1005.48
R1645 GND.t10 GND.t150 1005.48
R1646 GND.t6 GND.t134 1005.48
R1647 GND.t32 GND.t67 1005.48
R1648 GND.t13 GND.t90 1005.48
R1649 GND.t80 GND.t81 1005.48
R1650 GND GND.t123 971.635
R1651 GND GND.t42 971.635
R1652 GND GND.t47 963.735
R1653 GND.t121 GND.t18 948.504
R1654 GND.t33 GND.t14 948.504
R1655 GND GND.t141 930.938
R1656 GND GND.t242 930.938
R1657 GND.t202 GND.t129 929.942
R1658 GND.t4 GND.t97 929.942
R1659 GND.t11 GND.t167 929.942
R1660 GND.t143 GND.t68 929.942
R1661 GND.t250 GND 925.567
R1662 GND GND.t218 912.721
R1663 GND GND.t256 912.721
R1664 GND.t161 GND 912.721
R1665 GND.t212 GND 912.721
R1666 GND.t264 GND 911.327
R1667 GND.t119 GND.t139 904.591
R1668 GND GND.t31 887.027
R1669 GND GND.t30 887.027
R1670 GND GND.t20 887.027
R1671 GND.t176 GND.t135 876.783
R1672 GND.t178 GND.t101 876.783
R1673 GND.t192 GND.t148 876.783
R1674 GND.t174 GND.t82 876.783
R1675 GND.t180 GND.t84 876.783
R1676 GND.t188 GND.t86 876.783
R1677 GND GND.t131 869.668
R1678 GND GND.t145 869.668
R1679 GND.t77 GND 869.668
R1680 GND.t70 GND 869.668
R1681 GND.t51 GND.t125 853.143
R1682 GND.t55 GND.t57 853.143
R1683 GND.t28 GND.t26 851.896
R1684 GND.t137 GND.t16 851.896
R1685 GND.t63 GND 837.343
R1686 GND.t41 GND.t61 837.343
R1687 GND.t99 GND.t146 835.226
R1688 GND.t216 GND.t93 835.226
R1689 GND.t0 GND.t75 835.226
R1690 GND.t65 GND.t159 835.226
R1691 GND GND.t200 825.549
R1692 GND GND.t117 825.549
R1693 GND.t146 GND.n198 809.394
R1694 GND GND.t224 809.394
R1695 GND GND.t206 809.394
R1696 GND.n433 GND.t0 809.394
R1697 GND.t244 GND 809.394
R1698 GND.t165 GND 809.394
R1699 GND.n432 GND.n431 804.062
R1700 GND.n557 GND.n461 804.062
R1701 GND.n460 GND.n459 804.062
R1702 GND.t23 GND 797.846
R1703 GND.t43 GND 797.846
R1704 GND.t104 GND.t44 772.212
R1705 GND.t72 GND.t176 772.212
R1706 GND.t151 GND.t10 772.212
R1707 GND.t150 GND.t178 772.212
R1708 GND.t186 GND.t6 772.212
R1709 GND.t134 GND.t192 772.212
R1710 GND.t91 GND.t32 772.212
R1711 GND.t67 GND.t174 772.212
R1712 GND.t88 GND.t13 772.212
R1713 GND.t90 GND.t180 772.212
R1714 GND.t78 GND.t80 772.212
R1715 GND.t81 GND.t188 772.212
R1716 GND.t53 GND.t59 766.249
R1717 GND.t39 GND.t41 758.348
R1718 GND.t139 GND.t198 746.508
R1719 GND.t95 GND 742.549
R1720 GND.t31 GND.t45 737.726
R1721 GND.t200 GND.t28 737.726
R1722 GND.t30 GND.t121 737.726
R1723 GND.t20 GND.t33 737.726
R1724 GND.t117 GND.t137 737.726
R1725 GND.t196 GND.t238 737.726
R1726 GND.t198 GND.t240 737.726
R1727 GND.t224 GND.t99 723.288
R1728 GND.t131 GND.t202 723.288
R1729 GND.t145 GND.t4 723.288
R1730 GND.t206 GND.t216 723.288
R1731 GND.t222 GND.t260 723.288
R1732 GND.t75 GND.t244 723.288
R1733 GND.t167 GND.t77 723.288
R1734 GND.t68 GND.t70 723.288
R1735 GND.t159 GND.t165 723.288
R1736 GND.t210 GND.t248 723.288
R1737 GND.t61 GND.t21 695.154
R1738 GND.n200 GND.n199 675.687
R1739 GND.n564 GND.n563 675.687
R1740 GND.n559 GND.n558 663.556
R1741 GND.t125 GND.t23 663.556
R1742 GND.t59 GND.t95 663.556
R1743 GND.t57 GND.t43 663.556
R1744 GND.t42 GND.t37 663.556
R1745 GND.n199 GND 654.404
R1746 GND.n563 GND 654.404
R1747 GND GND.n161 625.381
R1748 GND GND.n562 625.381
R1749 GND.n431 GND.t2 587.092
R1750 GND.t24 GND.n557 587.092
R1751 GND.n459 GND.t7 587.092
R1752 GND GND.t119 570.859
R1753 GND GND.t35 568.761
R1754 GND.t49 GND.t62 568.761
R1755 GND.t62 GND.t22 568.761
R1756 GND GND.t196 562.077
R1757 GND.t37 GND 552.962
R1758 GND GND.t222 551.077
R1759 GND.t248 GND 551.077
R1760 GND.t22 GND 513.466
R1761 GND.t21 GND 513.466
R1762 GND.t45 GND.n559 386.428
R1763 GND.t132 GND.t2 344.599
R1764 GND.t7 GND.t73 344.599
R1765 GND.t214 GND.t204 328.644
R1766 GND.t157 GND.t163 328.644
R1767 GND GND.t9 322.264
R1768 GND.t71 GND 322.264
R1769 GND.n198 GND 290.356
R1770 GND GND.n433 290.356
R1771 GND.n29 GND.t164 282.663
R1772 GND.n366 GND.t205 282.663
R1773 GND.n291 GND.t251 282.663
R1774 GND.n492 GND.t120 282.663
R1775 GND.n35 GND.t209 278.589
R1776 GND.n372 GND.t259 278.589
R1777 GND.n297 GND.t227 278.589
R1778 GND.n498 GND.t241 278.589
R1779 GND.t220 GND.t214 271.212
R1780 GND.t246 GND.t157 271.212
R1781 GND.t9 GND.t132 268.021
R1782 GND.t258 GND.t220 268.021
R1783 GND.t73 GND.t71 268.021
R1784 GND.t208 GND.t246 268.021
R1785 GND.n441 GND.t245 246.506
R1786 GND.n23 GND.t166 246.506
R1787 GND.n170 GND.t225 246.506
R1788 GND.n360 GND.t207 246.506
R1789 GND.n242 GND.t267 246.506
R1790 GND.n285 GND.t255 246.506
R1791 GND.n469 GND.t201 246.506
R1792 GND.n486 GND.t118 246.506
R1793 GND.n71 GND.t96 246.506
R1794 GND.n446 GND.n440 210.601
R1795 GND.n46 GND.n22 210.601
R1796 GND.n418 GND.n168 210.601
R1797 GND.n383 GND.n359 210.601
R1798 GND.n262 GND.n261 210.601
R1799 GND.n308 GND.n284 210.601
R1800 GND.n544 GND.n467 210.601
R1801 GND.n509 GND.n485 210.601
R1802 GND.n73 GND.n72 210.601
R1803 GND.n86 GND.n85 208.553
R1804 GND.t204 GND 207.398
R1805 GND.t163 GND 207.398
R1806 GND.n437 GND.n436 204.457
R1807 GND.n609 GND.n10 204.457
R1808 GND.n19 GND.n18 204.457
R1809 GND.n426 GND.n165 204.457
R1810 GND.n347 GND.n346 204.457
R1811 GND.n356 GND.n355 204.457
R1812 GND.n247 GND.n246 204.457
R1813 GND.n240 GND.n239 204.457
R1814 GND.n281 GND.n280 204.457
R1815 GND.n552 GND.n464 204.457
R1816 GND.n473 GND.n472 204.457
R1817 GND.n482 GND.n481 204.457
R1818 GND.n625 GND.n2 204.457
R1819 GND.n122 GND.n79 204.457
R1820 GND.n559 GND.t24 204.207
R1821 GND.n33 GND.n27 200.127
R1822 GND.n370 GND.n364 200.127
R1823 GND.n295 GND.n289 200.127
R1824 GND.n496 GND.n490 200.127
R1825 GND.n147 GND.n146 199.739
R1826 GND.n585 GND.n153 199.739
R1827 GND.n569 GND.n159 199.739
R1828 GND.n184 GND.n183 199.739
R1829 GND.n221 GND.n190 199.739
R1830 GND.n205 GND.n196 199.739
R1831 GND.n134 GND.n132 185
R1832 GND.n136 GND.n135 185
R1833 GND.n594 GND.n593 185
R1834 GND.n592 GND.n150 185
R1835 GND.n577 GND.n576 185
R1836 GND.n579 GND.n578 185
R1837 GND.n181 GND.n180 185
R1838 GND.n179 GND.n178 185
R1839 GND.n230 GND.n229 185
R1840 GND.n228 GND.n187 185
R1841 GND.n213 GND.n212 185
R1842 GND.n215 GND.n214 185
R1843 GND.n13 GND.t162 158.361
R1844 GND.n15 GND.t213 158.361
R1845 GND.n401 GND.t219 158.361
R1846 GND.n352 GND.t257 158.361
R1847 GND.n275 GND.t237 158.361
R1848 GND.n277 GND.t229 158.361
R1849 GND.n527 GND.t142 158.361
R1850 GND.n478 GND.t243 158.361
R1851 GND.n81 GND.t36 158.361
R1852 GND.n84 GND.t64 158.361
R1853 GND.n25 GND.t249 156.915
R1854 GND.n362 GND.t223 156.915
R1855 GND.n287 GND.t265 156.915
R1856 GND.n488 GND.t197 156.915
R1857 GND.n40 GND.t211 154.131
R1858 GND.n377 GND.t261 154.131
R1859 GND.n302 GND.t231 154.131
R1860 GND.n503 GND.t239 154.131
R1861 GND.n199 GND.t258 153.155
R1862 GND.n563 GND.t208 153.155
R1863 GND.n95 GND.t38 150.922
R1864 GND.n91 GND.n90 114.376
R1865 GND.n90 GND.t40 108.505
R1866 GND.n85 GND.t50 101.43
R1867 GND.n578 GND.n577 97.1434
R1868 GND.n593 GND.n592 97.1434
R1869 GND.n135 GND.n134 97.1434
R1870 GND.n214 GND.n213 97.1434
R1871 GND.n229 GND.n228 97.1434
R1872 GND.n180 GND.n179 97.1434
R1873 GND.t135 GND 80.4393
R1874 GND.t101 GND 80.4393
R1875 GND.t148 GND 80.4393
R1876 GND.t82 GND 80.4393
R1877 GND.t84 GND 80.4393
R1878 GND.t86 GND 80.4393
R1879 GND.n146 GND.t175 74.2862
R1880 GND.n153 GND.t181 74.2862
R1881 GND.n159 GND.t189 74.2862
R1882 GND.n183 GND.t177 74.2862
R1883 GND.n190 GND.t179 74.2862
R1884 GND.n196 GND.t193 74.2862
R1885 GND.n436 GND.t74 72.8576
R1886 GND.n10 GND.t168 72.8576
R1887 GND.n18 GND.t69 72.8576
R1888 GND.n165 GND.t133 72.8576
R1889 GND.n346 GND.t203 72.8576
R1890 GND.n355 GND.t5 72.8576
R1891 GND.n246 GND.t128 72.8576
R1892 GND.n239 GND.t253 72.8576
R1893 GND.n280 GND.t113 72.8576
R1894 GND.n464 GND.t46 72.8576
R1895 GND.n472 GND.t122 72.8576
R1896 GND.n481 GND.t34 72.8576
R1897 GND.n2 GND.t126 72.8576
R1898 GND.n79 GND.t58 72.8576
R1899 GND.n577 GND.t79 61.4291
R1900 GND.n593 GND.t89 61.4291
R1901 GND.n134 GND.t92 61.4291
R1902 GND.n213 GND.t187 61.4291
R1903 GND.n229 GND.t152 61.4291
R1904 GND.n180 GND.t105 61.4291
R1905 GND.n440 GND.t76 55.7148
R1906 GND.n22 GND.t160 55.7148
R1907 GND.n168 GND.t100 55.7148
R1908 GND.n359 GND.t217 55.7148
R1909 GND.n261 GND.t116 55.7148
R1910 GND.n284 GND.t235 55.7148
R1911 GND.n467 GND.t29 55.7148
R1912 GND.n485 GND.t138 55.7148
R1913 GND.n72 GND.t60 55.7148
R1914 GND.n90 GND.t48 38.7697
R1915 GND.n578 GND.t191 38.5719
R1916 GND.n592 GND.t171 38.5719
R1917 GND.n135 GND.t173 38.5719
R1918 GND.n214 GND.t195 38.5719
R1919 GND.n228 GND.t183 38.5719
R1920 GND.n179 GND.t185 38.5719
R1921 GND.n457 GND.n434 34.6358
R1922 GND.n453 GND.n452 34.6358
R1923 GND.n452 GND.n451 34.6358
R1924 GND.n451 GND.n438 34.6358
R1925 GND.n447 GND.n438 34.6358
R1926 GND.n445 GND.n444 34.6358
R1927 GND.n611 GND.n9 34.6358
R1928 GND.n611 GND.n610 34.6358
R1929 GND.n608 GND.n11 34.6358
R1930 GND.n68 GND.n11 34.6358
R1931 GND.n68 GND.n67 34.6358
R1932 GND.n67 GND.n12 34.6358
R1933 GND.n63 GND.n62 34.6358
R1934 GND.n62 GND.n14 34.6358
R1935 GND.n58 GND.n57 34.6358
R1936 GND.n57 GND.n16 34.6358
R1937 GND.n53 GND.n52 34.6358
R1938 GND.n52 GND.n51 34.6358
R1939 GND.n51 GND.n20 34.6358
R1940 GND.n47 GND.n20 34.6358
R1941 GND.n45 GND.n44 34.6358
R1942 GND.n141 GND.n140 34.6358
R1943 GND.n141 GND.n130 34.6358
R1944 GND.n145 GND.n130 34.6358
R1945 GND.n600 GND.n599 34.6358
R1946 GND.n599 GND.n148 34.6358
R1947 GND.n591 GND.n590 34.6358
R1948 GND.n590 GND.n151 34.6358
R1949 GND.n586 GND.n151 34.6358
R1950 GND.n584 GND.n154 34.6358
R1951 GND.n580 GND.n154 34.6358
R1952 GND.n575 GND.n157 34.6358
R1953 GND.n571 GND.n157 34.6358
R1954 GND.n571 GND.n570 34.6358
R1955 GND.n339 GND.n182 34.6358
R1956 GND.n339 GND.n338 34.6358
R1957 GND.n338 GND.n337 34.6358
R1958 GND.n236 GND.n235 34.6358
R1959 GND.n235 GND.n185 34.6358
R1960 GND.n227 GND.n226 34.6358
R1961 GND.n226 GND.n188 34.6358
R1962 GND.n222 GND.n188 34.6358
R1963 GND.n220 GND.n191 34.6358
R1964 GND.n216 GND.n191 34.6358
R1965 GND.n211 GND.n194 34.6358
R1966 GND.n207 GND.n194 34.6358
R1967 GND.n207 GND.n206 34.6358
R1968 GND.n427 GND.n163 34.6358
R1969 GND.n425 GND.n424 34.6358
R1970 GND.n424 GND.n166 34.6358
R1971 GND.n420 GND.n166 34.6358
R1972 GND.n420 GND.n419 34.6358
R1973 GND.n417 GND.n169 34.6358
R1974 GND.n413 GND.n412 34.6358
R1975 GND.n412 GND.n171 34.6358
R1976 GND.n408 GND.n407 34.6358
R1977 GND.n407 GND.n406 34.6358
R1978 GND.n406 GND.n348 34.6358
R1979 GND.n402 GND.n348 34.6358
R1980 GND.n400 GND.n399 34.6358
R1981 GND.n399 GND.n351 34.6358
R1982 GND.n395 GND.n394 34.6358
R1983 GND.n394 GND.n353 34.6358
R1984 GND.n390 GND.n389 34.6358
R1985 GND.n389 GND.n388 34.6358
R1986 GND.n388 GND.n357 34.6358
R1987 GND.n384 GND.n357 34.6358
R1988 GND.n382 GND.n381 34.6358
R1989 GND.n251 GND.n250 34.6358
R1990 GND.n255 GND.n254 34.6358
R1991 GND.n256 GND.n255 34.6358
R1992 GND.n256 GND.n244 34.6358
R1993 GND.n260 GND.n244 34.6358
R1994 GND.n264 GND.n263 34.6358
R1995 GND.n268 GND.n267 34.6358
R1996 GND.n269 GND.n268 34.6358
R1997 GND.n273 GND.n272 34.6358
R1998 GND.n330 GND.n273 34.6358
R1999 GND.n330 GND.n329 34.6358
R2000 GND.n329 GND.n274 34.6358
R2001 GND.n325 GND.n324 34.6358
R2002 GND.n324 GND.n276 34.6358
R2003 GND.n320 GND.n319 34.6358
R2004 GND.n319 GND.n278 34.6358
R2005 GND.n315 GND.n314 34.6358
R2006 GND.n314 GND.n313 34.6358
R2007 GND.n313 GND.n282 34.6358
R2008 GND.n309 GND.n282 34.6358
R2009 GND.n307 GND.n306 34.6358
R2010 GND.n553 GND.n462 34.6358
R2011 GND.n551 GND.n550 34.6358
R2012 GND.n550 GND.n465 34.6358
R2013 GND.n546 GND.n465 34.6358
R2014 GND.n546 GND.n545 34.6358
R2015 GND.n543 GND.n468 34.6358
R2016 GND.n539 GND.n538 34.6358
R2017 GND.n538 GND.n470 34.6358
R2018 GND.n534 GND.n533 34.6358
R2019 GND.n533 GND.n532 34.6358
R2020 GND.n532 GND.n474 34.6358
R2021 GND.n528 GND.n474 34.6358
R2022 GND.n526 GND.n525 34.6358
R2023 GND.n525 GND.n477 34.6358
R2024 GND.n521 GND.n520 34.6358
R2025 GND.n520 GND.n479 34.6358
R2026 GND.n516 GND.n515 34.6358
R2027 GND.n515 GND.n514 34.6358
R2028 GND.n514 GND.n483 34.6358
R2029 GND.n510 GND.n483 34.6358
R2030 GND.n508 GND.n507 34.6358
R2031 GND.n627 GND.n626 34.6358
R2032 GND.n624 GND.n3 34.6358
R2033 GND.n620 GND.n3 34.6358
R2034 GND.n620 GND.n619 34.6358
R2035 GND.n619 GND.n4 34.6358
R2036 GND.n75 GND.n74 34.6358
R2037 GND.n124 GND.n78 34.6358
R2038 GND.n124 GND.n123 34.6358
R2039 GND.n121 GND.n80 34.6358
R2040 GND.n117 GND.n80 34.6358
R2041 GND.n117 GND.n116 34.6358
R2042 GND.n113 GND.n112 34.6358
R2043 GND.n112 GND.n111 34.6358
R2044 GND.n111 GND.n83 34.6358
R2045 GND.n107 GND.n106 34.6358
R2046 GND.n102 GND.n101 34.6358
R2047 GND.n101 GND.n100 34.6358
R2048 GND.n100 GND.n88 34.6358
R2049 GND.n96 GND.n88 34.6358
R2050 GND.n102 GND.n86 28.9887
R2051 GND.n94 GND.n91 27.4829
R2052 GND.n440 GND.t1 26.8576
R2053 GND.n22 GND.t66 26.8576
R2054 GND.n168 GND.t147 26.8576
R2055 GND.n359 GND.t94 26.8576
R2056 GND.n261 GND.t109 26.8576
R2057 GND.n284 GND.t156 26.8576
R2058 GND.n467 GND.t27 26.8576
R2059 GND.n485 GND.t17 26.8576
R2060 GND.n72 GND.t54 26.8576
R2061 GND.n39 GND.n25 25.977
R2062 GND.n33 GND.n32 25.977
R2063 GND.n32 GND.n29 25.977
R2064 GND.n376 GND.n362 25.977
R2065 GND.n370 GND.n369 25.977
R2066 GND.n369 GND.n366 25.977
R2067 GND.n301 GND.n287 25.977
R2068 GND.n295 GND.n294 25.977
R2069 GND.n294 GND.n291 25.977
R2070 GND.n502 GND.n488 25.977
R2071 GND.n496 GND.n495 25.977
R2072 GND.n495 GND.n492 25.977
R2073 GND.n85 GND.t124 25.9346
R2074 GND.n27 GND.t158 25.8467
R2075 GND.n364 GND.t215 25.8467
R2076 GND.n289 GND.t233 25.8467
R2077 GND.n490 GND.t140 25.8467
R2078 GND.n146 GND.t83 25.4291
R2079 GND.n153 GND.t85 25.4291
R2080 GND.n159 GND.t87 25.4291
R2081 GND.n183 GND.t136 25.4291
R2082 GND.n190 GND.t102 25.4291
R2083 GND.n196 GND.t149 25.4291
R2084 GND.n27 GND.t247 24.9236
R2085 GND.n364 GND.t221 24.9236
R2086 GND.n289 GND.t263 24.9236
R2087 GND.n490 GND.t199 24.9236
R2088 GND.n41 GND.n40 24.4711
R2089 GND.n40 GND.n39 24.4711
R2090 GND.n378 GND.n377 24.4711
R2091 GND.n377 GND.n376 24.4711
R2092 GND.n303 GND.n302 24.4711
R2093 GND.n302 GND.n301 24.4711
R2094 GND.n504 GND.n503 24.4711
R2095 GND.n503 GND.n502 24.4711
R2096 GND.n458 GND.n457 23.7181
R2097 GND.n568 GND.n565 23.7181
R2098 GND.n204 GND.n201 23.7181
R2099 GND.n430 GND.n163 23.7181
R2100 GND.n250 GND.n249 23.7181
R2101 GND.n556 GND.n462 23.7181
R2102 GND.n627 GND.n0 23.7181
R2103 GND.n95 GND.n94 23.7181
R2104 GND.n147 GND.n145 22.9652
R2105 GND.n586 GND.n585 22.9652
R2106 GND.n570 GND.n569 22.9652
R2107 GND.n337 GND.n184 22.9652
R2108 GND.n222 GND.n221 22.9652
R2109 GND.n206 GND.n205 22.9652
R2110 GND.n436 GND.t8 22.3257
R2111 GND.n10 GND.t12 22.3257
R2112 GND.n18 GND.t144 22.3257
R2113 GND.n165 GND.t3 22.3257
R2114 GND.n346 GND.t130 22.3257
R2115 GND.n355 GND.t98 22.3257
R2116 GND.n246 GND.t107 22.3257
R2117 GND.n239 GND.t111 22.3257
R2118 GND.n280 GND.t154 22.3257
R2119 GND.n464 GND.t25 22.3257
R2120 GND.n472 GND.t19 22.3257
R2121 GND.n481 GND.t15 22.3257
R2122 GND.n2 GND.t52 22.3257
R2123 GND.n79 GND.t56 22.3257
R2124 GND.n140 GND.n132 22.2496
R2125 GND.n594 GND.n591 22.2496
R2126 GND.n576 GND.n575 22.2496
R2127 GND.n182 GND.n181 22.2496
R2128 GND.n230 GND.n227 22.2496
R2129 GND.n212 GND.n211 22.2496
R2130 GND.n96 GND.n95 22.2123
R2131 GND.n600 GND.n147 21.4593
R2132 GND.n585 GND.n584 21.4593
R2133 GND.n569 GND.n568 21.4593
R2134 GND.n236 GND.n184 21.4593
R2135 GND.n221 GND.n220 21.4593
R2136 GND.n205 GND.n204 21.4593
R2137 GND.n106 GND.n86 21.4593
R2138 GND.n35 GND.n34 19.9534
R2139 GND.n372 GND.n371 19.9534
R2140 GND.n297 GND.n296 19.9534
R2141 GND.n498 GND.n497 19.9534
R2142 GND.n136 GND.n133 19.3675
R2143 GND.n178 GND.n177 19.3675
R2144 GND.n34 GND.n33 18.4476
R2145 GND.n371 GND.n370 18.4476
R2146 GND.n296 GND.n295 18.4476
R2147 GND.n497 GND.n496 18.4476
R2148 GND.n447 GND.n446 16.1887
R2149 GND.n47 GND.n46 16.1887
R2150 GND.n419 GND.n418 16.1887
R2151 GND.n384 GND.n383 16.1887
R2152 GND.n262 GND.n260 16.1887
R2153 GND.n309 GND.n308 16.1887
R2154 GND.n545 GND.n544 16.1887
R2155 GND.n510 GND.n509 16.1887
R2156 GND.n73 GND.n4 16.1887
R2157 GND.n444 GND.n441 15.0593
R2158 GND.n44 GND.n23 15.0593
R2159 GND.n35 GND.n25 15.0593
R2160 GND.n170 GND.n169 15.0593
R2161 GND.n381 GND.n360 15.0593
R2162 GND.n372 GND.n362 15.0593
R2163 GND.n264 GND.n242 15.0593
R2164 GND.n306 GND.n285 15.0593
R2165 GND.n297 GND.n287 15.0593
R2166 GND.n469 GND.n468 15.0593
R2167 GND.n507 GND.n486 15.0593
R2168 GND.n498 GND.n488 15.0593
R2169 GND.n75 GND.n71 15.0593
R2170 GND.n150 GND.n148 11.7085
R2171 GND.n580 GND.n579 11.7085
R2172 GND.n187 GND.n185 11.7085
R2173 GND.n216 GND.n215 11.7085
R2174 GND.n13 GND.n12 10.5417
R2175 GND.n15 GND.n14 10.5417
R2176 GND.n402 GND.n401 10.5417
R2177 GND.n352 GND.n351 10.5417
R2178 GND.n275 GND.n274 10.5417
R2179 GND.n277 GND.n276 10.5417
R2180 GND.n528 GND.n527 10.5417
R2181 GND.n478 GND.n477 10.5417
R2182 GND.n113 GND.n81 10.5417
R2183 GND.n84 GND.n83 10.5417
R2184 GND.n437 GND.n434 9.41227
R2185 GND.n610 GND.n609 9.41227
R2186 GND.n19 GND.n16 9.41227
R2187 GND.n427 GND.n426 9.41227
R2188 GND.n347 GND.n171 9.41227
R2189 GND.n356 GND.n353 9.41227
R2190 GND.n251 GND.n247 9.41227
R2191 GND.n269 GND.n240 9.41227
R2192 GND.n281 GND.n278 9.41227
R2193 GND.n553 GND.n552 9.41227
R2194 GND.n473 GND.n470 9.41227
R2195 GND.n482 GND.n479 9.41227
R2196 GND.n626 GND.n625 9.41227
R2197 GND.n123 GND.n122 9.41227
R2198 GND.n458 GND 9.3031
R2199 GND.n430 GND 9.3031
R2200 GND.n249 GND 9.3031
R2201 GND.n556 GND 9.3031
R2202 GND GND.n0 9.3031
R2203 GND.n30 GND.n29 9.3005
R2204 GND.n32 GND.n31 9.3005
R2205 GND.n33 GND.n28 9.3005
R2206 GND.n34 GND.n26 9.3005
R2207 GND.n36 GND.n35 9.3005
R2208 GND.n37 GND.n25 9.3005
R2209 GND.n457 GND.n456 9.3005
R2210 GND.n455 GND.n434 9.3005
R2211 GND.n454 GND.n453 9.3005
R2212 GND.n452 GND.n435 9.3005
R2213 GND.n451 GND.n450 9.3005
R2214 GND.n449 GND.n438 9.3005
R2215 GND.n448 GND.n447 9.3005
R2216 GND.n445 GND.n439 9.3005
R2217 GND.n444 GND.n443 9.3005
R2218 GND.n442 GND.n9 9.3005
R2219 GND.n612 GND.n611 9.3005
R2220 GND.n610 GND.n8 9.3005
R2221 GND.n608 GND.n607 9.3005
R2222 GND.n606 GND.n11 9.3005
R2223 GND.n69 GND.n68 9.3005
R2224 GND.n67 GND.n66 9.3005
R2225 GND.n65 GND.n12 9.3005
R2226 GND.n64 GND.n63 9.3005
R2227 GND.n62 GND.n61 9.3005
R2228 GND.n60 GND.n14 9.3005
R2229 GND.n59 GND.n58 9.3005
R2230 GND.n57 GND.n56 9.3005
R2231 GND.n55 GND.n16 9.3005
R2232 GND.n54 GND.n53 9.3005
R2233 GND.n52 GND.n17 9.3005
R2234 GND.n51 GND.n50 9.3005
R2235 GND.n49 GND.n20 9.3005
R2236 GND.n48 GND.n47 9.3005
R2237 GND.n45 GND.n21 9.3005
R2238 GND.n44 GND.n43 9.3005
R2239 GND.n42 GND.n41 9.3005
R2240 GND.n40 GND.n24 9.3005
R2241 GND.n39 GND.n38 9.3005
R2242 GND.n566 GND.n565 9.3005
R2243 GND.n138 GND.n137 9.3005
R2244 GND.n140 GND.n139 9.3005
R2245 GND.n142 GND.n141 9.3005
R2246 GND.n143 GND.n130 9.3005
R2247 GND.n145 GND.n144 9.3005
R2248 GND.n147 GND.n129 9.3005
R2249 GND.n601 GND.n600 9.3005
R2250 GND.n599 GND.n598 9.3005
R2251 GND.n597 GND.n148 9.3005
R2252 GND.n596 GND.n595 9.3005
R2253 GND.n591 GND.n149 9.3005
R2254 GND.n590 GND.n589 9.3005
R2255 GND.n588 GND.n151 9.3005
R2256 GND.n587 GND.n586 9.3005
R2257 GND.n585 GND.n152 9.3005
R2258 GND.n584 GND.n583 9.3005
R2259 GND.n582 GND.n154 9.3005
R2260 GND.n581 GND.n580 9.3005
R2261 GND.n156 GND.n155 9.3005
R2262 GND.n575 GND.n574 9.3005
R2263 GND.n573 GND.n157 9.3005
R2264 GND.n572 GND.n571 9.3005
R2265 GND.n570 GND.n158 9.3005
R2266 GND.n569 GND.n160 9.3005
R2267 GND.n568 GND.n567 9.3005
R2268 GND.n202 GND.n201 9.3005
R2269 GND.n176 GND.n175 9.3005
R2270 GND.n182 GND.n173 9.3005
R2271 GND.n340 GND.n339 9.3005
R2272 GND.n338 GND.n174 9.3005
R2273 GND.n337 GND.n336 9.3005
R2274 GND.n335 GND.n184 9.3005
R2275 GND.n237 GND.n236 9.3005
R2276 GND.n235 GND.n234 9.3005
R2277 GND.n233 GND.n185 9.3005
R2278 GND.n232 GND.n231 9.3005
R2279 GND.n227 GND.n186 9.3005
R2280 GND.n226 GND.n225 9.3005
R2281 GND.n224 GND.n188 9.3005
R2282 GND.n223 GND.n222 9.3005
R2283 GND.n221 GND.n189 9.3005
R2284 GND.n220 GND.n219 9.3005
R2285 GND.n218 GND.n191 9.3005
R2286 GND.n217 GND.n216 9.3005
R2287 GND.n193 GND.n192 9.3005
R2288 GND.n211 GND.n210 9.3005
R2289 GND.n209 GND.n194 9.3005
R2290 GND.n208 GND.n207 9.3005
R2291 GND.n206 GND.n195 9.3005
R2292 GND.n205 GND.n197 9.3005
R2293 GND.n204 GND.n203 9.3005
R2294 GND.n367 GND.n366 9.3005
R2295 GND.n369 GND.n368 9.3005
R2296 GND.n370 GND.n365 9.3005
R2297 GND.n371 GND.n363 9.3005
R2298 GND.n373 GND.n372 9.3005
R2299 GND.n374 GND.n362 9.3005
R2300 GND.n429 GND.n163 9.3005
R2301 GND.n428 GND.n427 9.3005
R2302 GND.n425 GND.n164 9.3005
R2303 GND.n424 GND.n423 9.3005
R2304 GND.n422 GND.n166 9.3005
R2305 GND.n421 GND.n420 9.3005
R2306 GND.n419 GND.n167 9.3005
R2307 GND.n417 GND.n416 9.3005
R2308 GND.n415 GND.n169 9.3005
R2309 GND.n414 GND.n413 9.3005
R2310 GND.n412 GND.n411 9.3005
R2311 GND.n410 GND.n171 9.3005
R2312 GND.n409 GND.n408 9.3005
R2313 GND.n407 GND.n345 9.3005
R2314 GND.n406 GND.n405 9.3005
R2315 GND.n404 GND.n348 9.3005
R2316 GND.n403 GND.n402 9.3005
R2317 GND.n400 GND.n350 9.3005
R2318 GND.n399 GND.n398 9.3005
R2319 GND.n397 GND.n351 9.3005
R2320 GND.n396 GND.n395 9.3005
R2321 GND.n394 GND.n393 9.3005
R2322 GND.n392 GND.n353 9.3005
R2323 GND.n391 GND.n390 9.3005
R2324 GND.n389 GND.n354 9.3005
R2325 GND.n388 GND.n387 9.3005
R2326 GND.n386 GND.n357 9.3005
R2327 GND.n385 GND.n384 9.3005
R2328 GND.n382 GND.n358 9.3005
R2329 GND.n381 GND.n380 9.3005
R2330 GND.n379 GND.n378 9.3005
R2331 GND.n377 GND.n361 9.3005
R2332 GND.n376 GND.n375 9.3005
R2333 GND.n292 GND.n291 9.3005
R2334 GND.n294 GND.n293 9.3005
R2335 GND.n295 GND.n290 9.3005
R2336 GND.n296 GND.n288 9.3005
R2337 GND.n298 GND.n297 9.3005
R2338 GND.n299 GND.n287 9.3005
R2339 GND.n250 GND.n248 9.3005
R2340 GND.n252 GND.n251 9.3005
R2341 GND.n254 GND.n253 9.3005
R2342 GND.n255 GND.n245 9.3005
R2343 GND.n257 GND.n256 9.3005
R2344 GND.n258 GND.n244 9.3005
R2345 GND.n260 GND.n259 9.3005
R2346 GND.n263 GND.n243 9.3005
R2347 GND.n265 GND.n264 9.3005
R2348 GND.n267 GND.n266 9.3005
R2349 GND.n268 GND.n241 9.3005
R2350 GND.n270 GND.n269 9.3005
R2351 GND.n272 GND.n271 9.3005
R2352 GND.n273 GND.n238 9.3005
R2353 GND.n331 GND.n330 9.3005
R2354 GND.n329 GND.n328 9.3005
R2355 GND.n327 GND.n274 9.3005
R2356 GND.n326 GND.n325 9.3005
R2357 GND.n324 GND.n323 9.3005
R2358 GND.n322 GND.n276 9.3005
R2359 GND.n321 GND.n320 9.3005
R2360 GND.n319 GND.n318 9.3005
R2361 GND.n317 GND.n278 9.3005
R2362 GND.n316 GND.n315 9.3005
R2363 GND.n314 GND.n279 9.3005
R2364 GND.n313 GND.n312 9.3005
R2365 GND.n311 GND.n282 9.3005
R2366 GND.n310 GND.n309 9.3005
R2367 GND.n307 GND.n283 9.3005
R2368 GND.n306 GND.n305 9.3005
R2369 GND.n304 GND.n303 9.3005
R2370 GND.n302 GND.n286 9.3005
R2371 GND.n301 GND.n300 9.3005
R2372 GND.n493 GND.n492 9.3005
R2373 GND.n495 GND.n494 9.3005
R2374 GND.n496 GND.n491 9.3005
R2375 GND.n497 GND.n489 9.3005
R2376 GND.n499 GND.n498 9.3005
R2377 GND.n500 GND.n488 9.3005
R2378 GND.n555 GND.n462 9.3005
R2379 GND.n554 GND.n553 9.3005
R2380 GND.n551 GND.n463 9.3005
R2381 GND.n550 GND.n549 9.3005
R2382 GND.n548 GND.n465 9.3005
R2383 GND.n547 GND.n546 9.3005
R2384 GND.n545 GND.n466 9.3005
R2385 GND.n543 GND.n542 9.3005
R2386 GND.n541 GND.n468 9.3005
R2387 GND.n540 GND.n539 9.3005
R2388 GND.n538 GND.n537 9.3005
R2389 GND.n536 GND.n470 9.3005
R2390 GND.n535 GND.n534 9.3005
R2391 GND.n533 GND.n471 9.3005
R2392 GND.n532 GND.n531 9.3005
R2393 GND.n530 GND.n474 9.3005
R2394 GND.n529 GND.n528 9.3005
R2395 GND.n526 GND.n476 9.3005
R2396 GND.n525 GND.n524 9.3005
R2397 GND.n523 GND.n477 9.3005
R2398 GND.n522 GND.n521 9.3005
R2399 GND.n520 GND.n519 9.3005
R2400 GND.n518 GND.n479 9.3005
R2401 GND.n517 GND.n516 9.3005
R2402 GND.n515 GND.n480 9.3005
R2403 GND.n514 GND.n513 9.3005
R2404 GND.n512 GND.n483 9.3005
R2405 GND.n511 GND.n510 9.3005
R2406 GND.n508 GND.n484 9.3005
R2407 GND.n507 GND.n506 9.3005
R2408 GND.n505 GND.n504 9.3005
R2409 GND.n503 GND.n487 9.3005
R2410 GND.n502 GND.n501 9.3005
R2411 GND.n628 GND.n627 9.3005
R2412 GND.n626 GND.n1 9.3005
R2413 GND.n624 GND.n623 9.3005
R2414 GND.n622 GND.n3 9.3005
R2415 GND.n621 GND.n620 9.3005
R2416 GND.n619 GND.n618 9.3005
R2417 GND.n617 GND.n4 9.3005
R2418 GND.n74 GND.n5 9.3005
R2419 GND.n76 GND.n75 9.3005
R2420 GND.n78 GND.n77 9.3005
R2421 GND.n125 GND.n124 9.3005
R2422 GND.n123 GND.n70 9.3005
R2423 GND.n121 GND.n120 9.3005
R2424 GND.n119 GND.n80 9.3005
R2425 GND.n118 GND.n117 9.3005
R2426 GND.n116 GND.n115 9.3005
R2427 GND.n114 GND.n113 9.3005
R2428 GND.n112 GND.n82 9.3005
R2429 GND.n111 GND.n110 9.3005
R2430 GND.n109 GND.n83 9.3005
R2431 GND.n108 GND.n107 9.3005
R2432 GND.n106 GND.n105 9.3005
R2433 GND.n104 GND.n86 9.3005
R2434 GND.n103 GND.n102 9.3005
R2435 GND.n101 GND.n87 9.3005
R2436 GND.n100 GND.n99 9.3005
R2437 GND.n98 GND.n88 9.3005
R2438 GND.n97 GND.n96 9.3005
R2439 GND.n95 GND.n89 9.3005
R2440 GND.n94 GND.n93 9.3005
R2441 GND.n342 GND.n172 8.51182
R2442 GND.n333 GND.n332 8.50906
R2443 GND.n615 GND.n6 8.48003
R2444 GND.n475 GND.n127 8.47865
R2445 GND.n605 GND.n604 7.9105
R2446 GND.n603 GND.n602 7.9105
R2447 GND.n334 GND.n333 7.9105
R2448 GND.n349 GND.n128 7.9105
R2449 GND.n342 GND.n341 7.9105
R2450 GND.n344 GND.n343 7.9105
R2451 GND.n131 GND.n7 7.9105
R2452 GND.n614 GND.n613 7.9105
R2453 GND.n127 GND.n126 7.9105
R2454 GND.n616 GND.n615 7.9105
R2455 GND.n92 GND.n91 7.01945
R2456 GND.n63 GND.n13 6.77697
R2457 GND.n58 GND.n15 6.77697
R2458 GND.n401 GND.n400 6.77697
R2459 GND.n395 GND.n352 6.77697
R2460 GND.n325 GND.n275 6.77697
R2461 GND.n320 GND.n277 6.77697
R2462 GND.n527 GND.n526 6.77697
R2463 GND.n521 GND.n478 6.77697
R2464 GND.n116 GND.n81 6.77697
R2465 GND.n107 GND.n84 6.77697
R2466 GND.n453 GND.n437 6.4005
R2467 GND.n609 GND.n608 6.4005
R2468 GND.n53 GND.n19 6.4005
R2469 GND.n426 GND.n425 6.4005
R2470 GND.n408 GND.n347 6.4005
R2471 GND.n390 GND.n356 6.4005
R2472 GND.n254 GND.n247 6.4005
R2473 GND.n272 GND.n240 6.4005
R2474 GND.n315 GND.n281 6.4005
R2475 GND.n552 GND.n551 6.4005
R2476 GND.n534 GND.n473 6.4005
R2477 GND.n516 GND.n482 6.4005
R2478 GND.n625 GND.n624 6.4005
R2479 GND.n122 GND.n121 6.4005
R2480 GND.n137 GND.n136 4.35795
R2481 GND.n595 GND.n150 4.35795
R2482 GND.n579 GND.n156 4.35795
R2483 GND.n178 GND.n175 4.35795
R2484 GND.n231 GND.n187 4.35795
R2485 GND.n215 GND.n193 4.35795
R2486 GND.n446 GND.n445 2.25932
R2487 GND.n46 GND.n45 2.25932
R2488 GND.n418 GND.n417 2.25932
R2489 GND.n383 GND.n382 2.25932
R2490 GND.n263 GND.n262 2.25932
R2491 GND.n308 GND.n307 2.25932
R2492 GND.n544 GND.n543 2.25932
R2493 GND.n509 GND.n508 2.25932
R2494 GND.n74 GND.n73 2.25932
R2495 GND.n137 GND.n132 1.8161
R2496 GND.n595 GND.n594 1.8161
R2497 GND.n576 GND.n156 1.8161
R2498 GND.n181 GND.n175 1.8161
R2499 GND.n231 GND.n230 1.8161
R2500 GND.n212 GND.n193 1.8161
R2501 GND.n441 GND.n9 1.50638
R2502 GND.n41 GND.n23 1.50638
R2503 GND.n413 GND.n170 1.50638
R2504 GND.n378 GND.n360 1.50638
R2505 GND.n267 GND.n242 1.50638
R2506 GND.n303 GND.n285 1.50638
R2507 GND.n539 GND.n469 1.50638
R2508 GND.n504 GND.n486 1.50638
R2509 GND.n78 GND.n71 1.50638
R2510 GND.n615 GND.n614 0.607353
R2511 GND.n604 GND.n127 0.605971
R2512 GND.n603 GND.n128 0.600441
R2513 GND.n343 GND.n7 0.600441
R2514 GND.n92 GND 0.588635
R2515 GND.n333 GND.n128 0.576941
R2516 GND.n614 GND.n7 0.576941
R2517 GND.n604 GND.n603 0.575559
R2518 GND.n343 GND.n342 0.574176
R2519 GND.n93 GND.n92 0.156212
R2520 GND.n138 GND.n133 0.141218
R2521 GND.n177 GND.n176 0.141218
R2522 GND.n456 GND.n455 0.120292
R2523 GND.n455 GND.n454 0.120292
R2524 GND.n454 GND.n435 0.120292
R2525 GND.n450 GND.n435 0.120292
R2526 GND.n449 GND.n448 0.120292
R2527 GND.n448 GND.n439 0.120292
R2528 GND.n443 GND.n439 0.120292
R2529 GND.n443 GND.n442 0.120292
R2530 GND.n612 GND.n8 0.120292
R2531 GND.n607 GND.n8 0.120292
R2532 GND.n607 GND.n606 0.120292
R2533 GND.n66 GND.n65 0.120292
R2534 GND.n65 GND.n64 0.120292
R2535 GND.n61 GND.n60 0.120292
R2536 GND.n60 GND.n59 0.120292
R2537 GND.n56 GND.n55 0.120292
R2538 GND.n55 GND.n54 0.120292
R2539 GND.n54 GND.n17 0.120292
R2540 GND.n50 GND.n17 0.120292
R2541 GND.n49 GND.n48 0.120292
R2542 GND.n48 GND.n21 0.120292
R2543 GND.n43 GND.n21 0.120292
R2544 GND.n43 GND.n42 0.120292
R2545 GND.n38 GND.n24 0.120292
R2546 GND.n38 GND.n37 0.120292
R2547 GND.n36 GND.n26 0.120292
R2548 GND.n28 GND.n26 0.120292
R2549 GND.n31 GND.n28 0.120292
R2550 GND.n31 GND.n30 0.120292
R2551 GND.n139 GND.n138 0.120292
R2552 GND.n143 GND.n142 0.120292
R2553 GND.n144 GND.n143 0.120292
R2554 GND.n144 GND.n129 0.120292
R2555 GND.n598 GND.n597 0.120292
R2556 GND.n597 GND.n596 0.120292
R2557 GND.n596 GND.n149 0.120292
R2558 GND.n589 GND.n149 0.120292
R2559 GND.n589 GND.n588 0.120292
R2560 GND.n588 GND.n587 0.120292
R2561 GND.n587 GND.n152 0.120292
R2562 GND.n583 GND.n152 0.120292
R2563 GND.n582 GND.n581 0.120292
R2564 GND.n581 GND.n155 0.120292
R2565 GND.n574 GND.n155 0.120292
R2566 GND.n574 GND.n573 0.120292
R2567 GND.n573 GND.n572 0.120292
R2568 GND.n572 GND.n158 0.120292
R2569 GND.n160 GND.n158 0.120292
R2570 GND.n567 GND.n160 0.120292
R2571 GND.n176 GND.n173 0.120292
R2572 GND.n340 GND.n174 0.120292
R2573 GND.n336 GND.n174 0.120292
R2574 GND.n336 GND.n335 0.120292
R2575 GND.n234 GND.n233 0.120292
R2576 GND.n233 GND.n232 0.120292
R2577 GND.n232 GND.n186 0.120292
R2578 GND.n225 GND.n186 0.120292
R2579 GND.n225 GND.n224 0.120292
R2580 GND.n224 GND.n223 0.120292
R2581 GND.n223 GND.n189 0.120292
R2582 GND.n219 GND.n189 0.120292
R2583 GND.n218 GND.n217 0.120292
R2584 GND.n217 GND.n192 0.120292
R2585 GND.n210 GND.n192 0.120292
R2586 GND.n210 GND.n209 0.120292
R2587 GND.n209 GND.n208 0.120292
R2588 GND.n208 GND.n195 0.120292
R2589 GND.n197 GND.n195 0.120292
R2590 GND.n203 GND.n197 0.120292
R2591 GND.n429 GND.n428 0.120292
R2592 GND.n428 GND.n164 0.120292
R2593 GND.n423 GND.n164 0.120292
R2594 GND.n423 GND.n422 0.120292
R2595 GND.n421 GND.n167 0.120292
R2596 GND.n416 GND.n167 0.120292
R2597 GND.n416 GND.n415 0.120292
R2598 GND.n415 GND.n414 0.120292
R2599 GND.n411 GND.n410 0.120292
R2600 GND.n410 GND.n409 0.120292
R2601 GND.n409 GND.n345 0.120292
R2602 GND.n404 GND.n403 0.120292
R2603 GND.n403 GND.n350 0.120292
R2604 GND.n398 GND.n397 0.120292
R2605 GND.n397 GND.n396 0.120292
R2606 GND.n393 GND.n392 0.120292
R2607 GND.n392 GND.n391 0.120292
R2608 GND.n391 GND.n354 0.120292
R2609 GND.n387 GND.n354 0.120292
R2610 GND.n386 GND.n385 0.120292
R2611 GND.n385 GND.n358 0.120292
R2612 GND.n380 GND.n358 0.120292
R2613 GND.n380 GND.n379 0.120292
R2614 GND.n375 GND.n361 0.120292
R2615 GND.n375 GND.n374 0.120292
R2616 GND.n373 GND.n363 0.120292
R2617 GND.n365 GND.n363 0.120292
R2618 GND.n368 GND.n365 0.120292
R2619 GND.n368 GND.n367 0.120292
R2620 GND.n252 GND.n248 0.120292
R2621 GND.n253 GND.n252 0.120292
R2622 GND.n253 GND.n245 0.120292
R2623 GND.n257 GND.n245 0.120292
R2624 GND.n259 GND.n258 0.120292
R2625 GND.n259 GND.n243 0.120292
R2626 GND.n265 GND.n243 0.120292
R2627 GND.n266 GND.n265 0.120292
R2628 GND.n270 GND.n241 0.120292
R2629 GND.n271 GND.n270 0.120292
R2630 GND.n271 GND.n238 0.120292
R2631 GND.n328 GND.n327 0.120292
R2632 GND.n327 GND.n326 0.120292
R2633 GND.n323 GND.n322 0.120292
R2634 GND.n322 GND.n321 0.120292
R2635 GND.n318 GND.n317 0.120292
R2636 GND.n317 GND.n316 0.120292
R2637 GND.n316 GND.n279 0.120292
R2638 GND.n312 GND.n279 0.120292
R2639 GND.n311 GND.n310 0.120292
R2640 GND.n310 GND.n283 0.120292
R2641 GND.n305 GND.n283 0.120292
R2642 GND.n305 GND.n304 0.120292
R2643 GND.n300 GND.n286 0.120292
R2644 GND.n300 GND.n299 0.120292
R2645 GND.n298 GND.n288 0.120292
R2646 GND.n290 GND.n288 0.120292
R2647 GND.n293 GND.n290 0.120292
R2648 GND.n293 GND.n292 0.120292
R2649 GND.n555 GND.n554 0.120292
R2650 GND.n554 GND.n463 0.120292
R2651 GND.n549 GND.n463 0.120292
R2652 GND.n549 GND.n548 0.120292
R2653 GND.n547 GND.n466 0.120292
R2654 GND.n542 GND.n466 0.120292
R2655 GND.n542 GND.n541 0.120292
R2656 GND.n541 GND.n540 0.120292
R2657 GND.n537 GND.n536 0.120292
R2658 GND.n536 GND.n535 0.120292
R2659 GND.n535 GND.n471 0.120292
R2660 GND.n530 GND.n529 0.120292
R2661 GND.n529 GND.n476 0.120292
R2662 GND.n524 GND.n523 0.120292
R2663 GND.n523 GND.n522 0.120292
R2664 GND.n519 GND.n518 0.120292
R2665 GND.n518 GND.n517 0.120292
R2666 GND.n517 GND.n480 0.120292
R2667 GND.n513 GND.n480 0.120292
R2668 GND.n512 GND.n511 0.120292
R2669 GND.n511 GND.n484 0.120292
R2670 GND.n506 GND.n484 0.120292
R2671 GND.n506 GND.n505 0.120292
R2672 GND.n501 GND.n487 0.120292
R2673 GND.n501 GND.n500 0.120292
R2674 GND.n499 GND.n489 0.120292
R2675 GND.n491 GND.n489 0.120292
R2676 GND.n494 GND.n491 0.120292
R2677 GND.n494 GND.n493 0.120292
R2678 GND.n628 GND.n1 0.120292
R2679 GND.n623 GND.n1 0.120292
R2680 GND.n623 GND.n622 0.120292
R2681 GND.n622 GND.n621 0.120292
R2682 GND.n618 GND.n617 0.120292
R2683 GND.n76 GND.n5 0.120292
R2684 GND.n77 GND.n76 0.120292
R2685 GND.n125 GND.n70 0.120292
R2686 GND.n120 GND.n70 0.120292
R2687 GND.n120 GND.n119 0.120292
R2688 GND.n119 GND.n118 0.120292
R2689 GND.n114 GND.n82 0.120292
R2690 GND.n110 GND.n109 0.120292
R2691 GND.n109 GND.n108 0.120292
R2692 GND.n105 GND.n104 0.120292
R2693 GND.n104 GND.n103 0.120292
R2694 GND.n103 GND.n87 0.120292
R2695 GND.n99 GND.n87 0.120292
R2696 GND.n98 GND.n97 0.120292
R2697 GND.n97 GND.n89 0.120292
R2698 GND.n602 GND.n601 0.115083
R2699 GND.n334 GND.n237 0.115083
R2700 GND.n605 GND.n69 0.104667
R2701 GND.n405 GND.n349 0.104667
R2702 GND.n332 GND.n331 0.104667
R2703 GND.n531 GND.n475 0.104667
R2704 GND GND.n114 0.0981562
R2705 GND.n133 GND 0.0975039
R2706 GND.n177 GND 0.0975039
R2707 GND.n616 GND.n5 0.09425
R2708 GND.n139 GND.n131 0.0890417
R2709 GND.n341 GND.n173 0.0890417
R2710 GND.n456 GND 0.0603958
R2711 GND GND.n449 0.0603958
R2712 GND.n66 GND 0.0603958
R2713 GND.n61 GND 0.0603958
R2714 GND.n56 GND 0.0603958
R2715 GND GND.n49 0.0603958
R2716 GND.n24 GND 0.0603958
R2717 GND GND.n36 0.0603958
R2718 GND.n598 GND 0.0603958
R2719 GND GND.n582 0.0603958
R2720 GND GND.n566 0.0603958
R2721 GND.n234 GND 0.0603958
R2722 GND GND.n218 0.0603958
R2723 GND GND.n202 0.0603958
R2724 GND GND.n429 0.0603958
R2725 GND GND.n421 0.0603958
R2726 GND GND.n404 0.0603958
R2727 GND.n398 GND 0.0603958
R2728 GND.n393 GND 0.0603958
R2729 GND GND.n386 0.0603958
R2730 GND.n361 GND 0.0603958
R2731 GND GND.n373 0.0603958
R2732 GND GND.n248 0.0603958
R2733 GND.n258 GND 0.0603958
R2734 GND.n328 GND 0.0603958
R2735 GND.n323 GND 0.0603958
R2736 GND.n318 GND 0.0603958
R2737 GND GND.n311 0.0603958
R2738 GND.n286 GND 0.0603958
R2739 GND GND.n298 0.0603958
R2740 GND GND.n555 0.0603958
R2741 GND GND.n547 0.0603958
R2742 GND GND.n530 0.0603958
R2743 GND.n524 GND 0.0603958
R2744 GND.n519 GND 0.0603958
R2745 GND GND.n512 0.0603958
R2746 GND.n487 GND 0.0603958
R2747 GND GND.n499 0.0603958
R2748 GND GND.n628 0.0603958
R2749 GND.n618 GND 0.0603958
R2750 GND.n115 GND 0.0603958
R2751 GND GND.n82 0.0603958
R2752 GND.n110 GND 0.0603958
R2753 GND.n105 GND 0.0603958
R2754 GND GND.n98 0.0603958
R2755 GND.n93 GND 0.0603958
R2756 GND.n126 GND.n125 0.0577917
R2757 GND.n613 GND 0.0395625
R2758 GND.n344 GND 0.0395625
R2759 GND GND.n172 0.0395625
R2760 GND GND.n6 0.0395625
R2761 GND.n566 GND 0.0330521
R2762 GND.n202 GND 0.0330521
R2763 GND.n142 GND.n131 0.03175
R2764 GND.n341 GND.n340 0.03175
R2765 GND.n617 GND.n616 0.0265417
R2766 GND GND.n89 0.0239375
R2767 GND.n450 GND 0.0226354
R2768 GND.n442 GND 0.0226354
R2769 GND.n69 GND 0.0226354
R2770 GND.n64 GND 0.0226354
R2771 GND.n59 GND 0.0226354
R2772 GND.n50 GND 0.0226354
R2773 GND.n42 GND 0.0226354
R2774 GND.n30 GND 0.0226354
R2775 GND.n422 GND 0.0226354
R2776 GND.n414 GND 0.0226354
R2777 GND.n405 GND 0.0226354
R2778 GND GND.n350 0.0226354
R2779 GND.n396 GND 0.0226354
R2780 GND.n387 GND 0.0226354
R2781 GND.n379 GND 0.0226354
R2782 GND.n367 GND 0.0226354
R2783 GND GND.n257 0.0226354
R2784 GND.n266 GND 0.0226354
R2785 GND.n331 GND 0.0226354
R2786 GND.n326 GND 0.0226354
R2787 GND.n321 GND 0.0226354
R2788 GND.n312 GND 0.0226354
R2789 GND.n304 GND 0.0226354
R2790 GND.n292 GND 0.0226354
R2791 GND.n548 GND 0.0226354
R2792 GND.n540 GND 0.0226354
R2793 GND.n531 GND 0.0226354
R2794 GND GND.n476 0.0226354
R2795 GND.n522 GND 0.0226354
R2796 GND.n513 GND 0.0226354
R2797 GND.n505 GND 0.0226354
R2798 GND.n493 GND 0.0226354
R2799 GND.n621 GND 0.0226354
R2800 GND.n77 GND 0.0226354
R2801 GND.n118 GND 0.0226354
R2802 GND.n115 GND 0.0226354
R2803 GND.n108 GND 0.0226354
R2804 GND.n99 GND 0.0226354
R2805 GND.n613 GND.n612 0.0213333
R2806 GND.n37 GND 0.0213333
R2807 GND.n601 GND 0.0213333
R2808 GND.n583 GND 0.0213333
R2809 GND.n567 GND 0.0213333
R2810 GND.n237 GND 0.0213333
R2811 GND.n219 GND 0.0213333
R2812 GND.n203 GND 0.0213333
R2813 GND.n411 GND.n344 0.0213333
R2814 GND.n374 GND 0.0213333
R2815 GND.n241 GND.n172 0.0213333
R2816 GND.n299 GND 0.0213333
R2817 GND.n537 GND.n6 0.0213333
R2818 GND.n500 GND 0.0213333
R2819 GND.n606 GND.n605 0.016125
R2820 GND.n349 GND.n345 0.016125
R2821 GND.n332 GND.n238 0.016125
R2822 GND.n475 GND.n471 0.016125
R2823 GND.n602 GND.n129 0.00570833
R2824 GND.n335 GND.n334 0.00570833
R2825 GND.n126 GND 0.00310417
C0 A[2] x4.x7.X 0.26778f
C1 A[15] x1.x3.X 0.21158f
C2 VDD x3.x6.Y 0.28832f
C3 A[7] A[6] 0.38787f
C4 a_2361_n3277# A[4] 0.18261f
C5 x3.x7.X x3.x5.Y 0.16041f
C6 x13.A0 x4.Z[1] 0.14879f
C7 x3.x3.X VDD 0.27521f
C8 A[15] x1.x2.Y 0.18756f
C9 a_2498_n477# x11.B 0.13305f
C10 x5.A x6.Y 0.28912f
C11 a_1542_n3985# Y[2] 0.31836f
C12 A[0] VDD 0.24039f
C13 x3.x7.X A[6] 0.26778f
C14 x3.x2.Y A[6] 0.26854f
C15 x4.x6.Y A[0] 0.15452f
C16 x16.X x4.Z[0] 0.10728f
C17 x4.x7.X VDD 0.21226f
C18 A[13] A[15] 0.18211f
C19 x2.x3.X a_898_n1355# 0.12052f
C20 x4.x8.X a_3281_n4977# 0.23074f
C21 VDD a_3281_123# 0.21758f
C22 VDD A[4] 0.28638f
C23 x16.X VDD 0.33547f
C24 a_1542_n3985# x4.Z[0] 0.19142f
C25 x2.x6.Y A[8] 0.15452f
C26 A[2] VDD 0.63601f
C27 x3.Z[2] A[5] 0.16742f
C28 x13.X Y[3] 0.17922f
C29 a_898_n4755# A[1] 0.1956f
C30 Y[2] x4.Z[0] 0.37371f
C31 x5.A VDD 1.60617f
C32 a_1542_n3985# VDD 0.11426f
C33 a_2361_n3277# VDD 0.21419f
C34 x2.x6.Y a_2361_n1577# 0.10994f
C35 Y[3] a_1143_n2463# 0.21371f
C36 Y[2] VDD 2.93441f
C37 VDD x6.Y 0.28692f
C38 VDD x2.x8.X 0.28996f
C39 x4.x3.X A[1] 0.10274f
C40 x13.A1 Y[2] 0.28653f
C41 x8.Y VDD 0.28975f
C42 x17.X Y[3] 0.26386f
C43 x4.x3.X a_1349_n4977# 0.22515f
C44 x5.A Y[4] 0.10542f
C45 x4.Z[2] A[1] 0.16821f
C46 a_65_n727# x2.Z[2] 0.16917f
C47 VDD x4.Z[0] 0.55036f
C48 a_898_345# VDD 0.16311f
C49 A[9] A[11] 0.18211f
C50 Y[3] x4.Z[2] 0.59805f
C51 VDD x2.x7.X 0.21351f
C52 A[15] A[12] 0.72998f
C53 a_2498_n477# x10.B 0.10791f
C54 x17.X a_1143_n4163# 0.31703f
C55 x2.x3.X a_1349_n1577# 0.22515f
C56 x4.x6.Y VDD 0.2863f
C57 A[6] A[4] 0.17687f
C58 x13.A1 VDD 1.2354f
C59 x1.x6.Y VDD 0.28837f
C60 x8.Y x11.B 0.2325f
C61 x3.Z[2] x4.Z[2] 2.2201f
C62 x14.X a_714_n2285# 0.191f
C63 A[8] x2.Z[2] 0.16221f
C64 A[15] A[14] 0.38787f
C65 Y[4] VDD 0.28749f
C66 a_2361_n4977# A[0] 0.18261f
C67 VDD a_1349_123# 0.21354f
C68 a_3281_n1577# x16.A1 0.118f
C69 A[10] x2.x7.X 0.26778f
C70 x4.x3.X A[3] 0.21158f
C71 x4.x7.X a_2361_n4977# 0.116f
C72 A[10] VDD 0.64186f
C73 VDD x11.B 0.24628f
C74 x3.x5.Y VDD 1.10025f
C75 x13.A1 A[10] 0.52834f
C76 x2.Z[2] x4.Z[2] 0.3066f
C77 a_2830_345# x1.x7.X 0.24515f
C78 VDD a_898_n1355# 0.16345f
C79 x1.x5.Y x1.x7.X 0.16041f
C80 VDD A[6] 0.64431f
C81 x8.Y x9.Y 0.19454f
C82 x5.A x10.B 0.29996f
C83 A[0] A[1] 0.99962f
C84 x1.x3.X a_898_345# 0.12052f
C85 VDD a_3281_n3277# 0.21758f
C86 x1.x3.X VDD 0.2749f
C87 x4.Z[1] a_1971_n2463# 0.13163f
C88 VDD a_2361_123# 0.21446f
C89 x13.A0 x16.A1 0.13584f
C90 x3.x8.X VDD 0.28953f
C91 x3.Z[1] VDD 1.15226f
C92 x5.A A[13] 0.20109f
C93 a_898_n3055# A[5] 0.1956f
C94 x17.A0 x16.A1 0.39862f
C95 A[2] A[1] 1.44123f
C96 A[8] A[9] 0.97906f
C97 x9.Y VDD 0.43346f
C98 x13.A0 x1.x5.Y 0.2445f
C99 a_2361_n4977# VDD 0.21178f
C100 x1.x6.Y a_2361_123# 0.10994f
C101 x4.x6.Y a_2361_n4977# 0.10994f
C102 x3.x5.Y A[6] 0.15469f
C103 A[14] a_2830_345# 0.11164f
C104 a_2830_345# x1.x8.X 0.1195f
C105 a_2799_n4163# x16.A1 0.14211f
C106 x1.x5.Y A[14] 0.15469f
C107 x17.X a_714_n3985# 0.18863f
C108 x1.x5.Y x1.x8.X 0.35353f
C109 x14.X x13.X 0.39873f
C110 x5.A Y[3] 0.20334f
C111 VDD x10.B 0.42018f
C112 VDD x1.x2.Y 0.87421f
C113 x3.Z[2] A[4] 0.16132f
C114 x1.x3.X a_1349_123# 0.22515f
C115 VDD a_1349_n1577# 0.214f
C116 x14.X a_1143_n2463# 0.28712f
C117 A[13] a_898_345# 0.1956f
C118 x2.x5.Y x2.x8.X 0.35353f
C119 a_3281_n1577# x2.x8.X 0.23074f
C120 x13.A1 a_1349_n1577# 0.11264f
C121 x4.x3.X x4.x2.Y 0.38043f
C122 x3.x5.Y x3.x8.X 0.35353f
C123 x5.A x3.Z[2] 0.2577f
C124 x3.x5.Y x3.Z[1] 0.24221f
C125 A[13] VDD 0.27146f
C126 A[0] A[3] 0.69229f
C127 x2.x6.Y VDD 0.28859f
C128 x3.Z[2] x6.Y 0.28645f
C129 VDD A[1] 0.26586f
C130 A[13] x1.x6.Y 0.1005f
C131 A[11] x2.x2.Y 0.18756f
C132 A[8] A[11] 0.67139f
C133 x4.x8.X a_2830_n4755# 0.1195f
C134 x4.x6.Y A[1] 0.1005f
C135 a_1349_n4977# VDD 0.21193f
C136 x2.x5.Y x2.x7.X 0.16041f
C137 x5.A A[12] 0.35957f
C138 Y[2] a_2370_n2285# 0.34717f
C139 Y[3] VDD 2.29384f
C140 x3.Z[1] A[6] 0.51713f
C141 x2.x5.Y VDD 1.10086f
C142 a_3281_n1577# VDD 0.21758f
C143 A[2] A[3] 0.38787f
C144 x13.A1 x2.x5.Y 0.24546f
C145 a_3281_123# x1.x8.X 0.23074f
C146 x2.x3.X A[9] 0.10274f
C147 x16.X a_1971_n4163# 0.1806f
C148 x5.A x2.Z[2] 0.44483f
C149 x3.x8.X a_3281_n3277# 0.23074f
C150 x3.x3.X a_1349_n3277# 0.22515f
C151 a_2370_n3985# x16.A1 0.19612f
C152 x3.Z[2] VDD 0.59528f
C153 VDD x1.x7.X 0.21415f
C154 x5.A A[14] 0.17762f
C155 x4.Z[1] a_1542_n2285# 0.1884f
C156 a_2029_n699# VDD 0.21739f
C157 a_898_345# A[12] 0.1164f
C158 x2.Z[2] x6.Y 0.2765f
C159 a_1143_n4163# VDD 0.15987f
C160 x13.A0 Y[2] 0.35238f
C161 a_2370_n2285# VDD 0.12972f
C162 Y[2] x17.A0 0.42041f
C163 x13.X a_1971_n2463# 0.18025f
C164 x13.A1 a_2370_n2285# 0.20229f
C165 Y[2] a_1971_n4163# 0.22178f
C166 VDD A[12] 0.29286f
C167 x2.x5.Y A[10] 0.15469f
C168 Y[2] a_2799_n4163# 0.24232f
C169 x1.x6.Y A[12] 0.15452f
C170 x1.x3.X x1.x2.Y 0.38043f
C171 Y[2] a_2799_n2463# 0.23189f
C172 x17.A0 x4.Z[0] 0.42714f
C173 VDD A[3] 0.3431f
C174 a_1971_n4163# x4.Z[0] 0.12843f
C175 x4.Z[1] x16.A1 0.24013f
C176 x4.x5.Y x4.Z[1] 0.24174f
C177 x2.Z[2] VDD 0.70178f
C178 x13.A0 VDD 1.12546f
C179 a_985_n727# x5.A 0.20632f
C180 x2.x3.X A[11] 0.21158f
C181 x4.x8.X x4.x5.Y 0.35353f
C182 a_2029_n699# x11.B 0.13074f
C183 VDD x17.A0 0.78418f
C184 x13.A1 x13.A0 1.00582f
C185 A[14] VDD 0.6426f
C186 a_3281_n4977# x4.Z[0] 0.11939f
C187 VDD x1.x8.X 0.29102f
C188 A[13] x1.x3.X 0.10274f
C189 a_1971_n4163# VDD 0.16338f
C190 a_985_n727# x6.Y 0.24063f
C191 a_2799_n4163# VDD 0.16596f
C192 Y[2] a_2949_n699# 0.1178f
C193 a_898_n3055# x3.x3.X 0.12052f
C194 VDD a_3281_n4977# 0.21745f
C195 x3.Z[2] A[6] 0.13812f
C196 a_2799_n2463# VDD 0.1566f
C197 x13.A0 a_1349_123# 0.11264f
C198 x13.A1 a_2799_n2463# 0.1397f
C199 x3.x7.X a_2830_n3055# 0.24515f
C200 A[7] A[5] 0.18211f
C201 a_65_n727# x4.Z[2] 0.23247f
C202 x2.Z[2] A[10] 0.1463f
C203 A[2] x4.x2.Y 0.26855f
C204 a_898_n3055# A[4] 0.1164f
C205 a_985_n727# VDD 0.22162f
C206 a_1349_n3277# VDD 0.21393f
C207 a_2361_123# x1.x7.X 0.116f
C208 VDD a_2949_n699# 0.22266f
C209 a_2370_n3985# Y[2] 0.34544f
C210 A[8] a_2361_n1577# 0.18261f
C211 x4.x3.X a_898_n4755# 0.12052f
C212 x3.Z[2] x9.Y 0.19397f
C213 x9.Y a_2029_n699# 0.19999f
C214 A[12] a_2361_123# 0.18261f
C215 a_714_n3985# VDD 0.10607f
C216 A[2] x4.Z[1] 0.5171f
C217 A[9] VDD 0.27019f
C218 a_2370_n3985# VDD 0.1277f
C219 x4.x2.Y VDD 0.87243f
C220 x17.A0 a_3281_n3277# 0.12222f
C221 Y[2] x4.Z[1] 1.10374f
C222 x3.x6.Y A[5] 0.1005f
C223 x14.X VDD 0.21819f
C224 a_898_n3055# VDD 0.16336f
C225 x4.Z[1] x4.Z[0] 0.2497f
C226 x2.x3.X x2.x2.Y 0.38043f
C227 A[9] A[10] 1.41923f
C228 A[13] A[12] 1.03876f
C229 Y[3] x3.Z[2] 0.46088f
C230 x3.x3.X A[5] 0.10274f
C231 Y[3] a_1143_n4163# 0.21701f
C232 x4.Z[1] VDD 1.03601f
C233 A[11] VDD 0.34755f
C234 A[14] x1.x2.Y 0.26855f
C235 x4.x8.X VDD 0.28937f
C236 A[7] x3.x2.Y 0.18756f
C237 A[9] a_898_n1355# 0.1956f
C238 VDD a_714_n2285# 0.10818f
C239 A[3] A[1] 0.18211f
C240 x3.Z[1] a_1349_n3277# 0.11264f
C241 A[5] A[4] 0.98592f
C242 A[13] A[14] 1.48313f
C243 Y[2] a_1971_n2463# 0.22312f
C244 x16.A0 x16.A1 0.34915f
C245 Y[3] x2.Z[2] 0.13661f
C246 a_65_n727# x5.A 0.21746f
C247 a_898_n4755# A[0] 0.1164f
C248 A[11] A[10] 0.38787f
C249 x4.x7.X a_2830_n4755# 0.24515f
C250 x10.B a_2949_n699# 0.23592f
C251 VDD a_2830_n3055# 0.16015f
C252 x3.Z[2] x2.Z[2] 0.77253f
C253 a_1971_n2463# VDD 0.14726f
C254 A[7] x3.x3.X 0.21158f
C255 A[2] a_2830_n4755# 0.11164f
C256 A[14] x1.x7.X 0.26778f
C257 x5.A A[15] 0.10263f
C258 x13.X Y[2] 0.13779f
C259 x17.X x16.X 0.44046f
C260 A[0] x4.Z[2] 0.16162f
C261 a_65_n727# VDD 0.38756f
C262 VDD A[5] 0.26925f
C263 A[14] A[12] 0.17687f
C264 A[7] A[4] 0.67839f
C265 x3.x3.X x3.x2.Y 0.38043f
C266 a_2830_n1355# x2.x8.X 0.1195f
C267 x16.A0 a_3281_123# 0.11764f
C268 x4.Z[1] x3.Z[1] 1.26133f
C269 A[2] x4.Z[2] 0.14089f
C270 x2.x6.Y A[9] 0.1005f
C271 x13.A0 A[14] 0.52631f
C272 x5.A x4.Z[2] 0.4375f
C273 x13.X VDD 0.95041f
C274 a_714_n3985# Y[3] 0.37287f
C275 A[15] VDD 0.35008f
C276 a_2830_n4755# VDD 0.15689f
C277 Y[0] VDD 0.2235f
C278 A[6] a_2830_n3055# 0.11164f
C279 a_898_n4755# VDD 0.16193f
C280 x6.Y x4.Z[2] 0.16912f
C281 VDD x2.x2.Y 0.87473f
C282 A[8] VDD 0.28607f
C283 Y[2] a_1542_n2285# 0.31873f
C284 a_2830_n1355# x2.x7.X 0.24515f
C285 a_1143_n2463# VDD 0.14702f
C286 x4.x7.X x4.x5.Y 0.16041f
C287 Y[2] x16.A0 1.83137f
C288 x8.Y x4.Z[2] 0.12766f
C289 a_2830_n1355# VDD 0.15996f
C290 x13.A0 a_2799_n2463# 0.11432f
C291 VDD Y[1] 0.25011f
C292 x2.x7.X a_2361_n1577# 0.116f
C293 x17.X VDD 0.28002f
C294 VDD a_2361_n1577# 0.21433f
C295 x4.x3.X VDD 0.27351f
C296 x14.X Y[3] 0.14693f
C297 A[2] x4.x5.Y 0.15469f
C298 x3.x8.X a_2830_n3055# 0.1195f
C299 x3.x7.X a_2361_n3277# 0.116f
C300 x3.x6.Y A[4] 0.15452f
C301 x16.A0 x4.Z[0] 0.17333f
C302 a_985_n727# x2.Z[2] 0.21953f
C303 A[7] VDD 0.3477f
C304 A[6] A[5] 1.42656f
C305 VDD x4.Z[2] 0.49519f
C306 Y[2] x16.A1 1.64512f
C307 x16.A0 VDD 0.4775f
C308 A[10] x2.x2.Y 0.26854f
C309 A[8] A[10] 0.17687f
C310 x4.Z[1] a_1349_n4977# 0.11264f
C311 A[10] a_2830_n1355# 0.11164f
C312 a_2361_n3277# x3.x6.Y 0.10994f
C313 x8.Y a_2498_n477# 0.19846f
C314 x2.Z[2] A[9] 0.1676f
C315 Y[3] a_714_n2285# 0.34396f
C316 A[8] a_898_n1355# 0.1164f
C317 x3.x2.Y VDD 0.87475f
C318 Y[4] x4.Z[2] 0.11252f
C319 x3.x7.X VDD 0.21358f
C320 x4.x2.Y A[3] 0.18756f
C321 VDD x16.A1 0.5572f
C322 x4.x5.Y VDD 1.09995f
C323 A[10] x4.Z[2] 0.10029f
C324 A[2] A[0] 0.17687f
C325 x2.x3.X VDD 0.27479f
C326 VDD a_2830_345# 0.15941f
C327 a_2498_n477# VDD 0.16993f
C328 x1.x5.Y VDD 1.10243f
C329 A[3] GND 1.71363f
C330 A[2] GND 1.16738f
C331 A[1] GND 0.64897f
C332 A[0] GND 1.53712f
C333 Y[0] GND 0.40372f
C334 A[7] GND 1.66544f
C335 A[6] GND 1.08737f
C336 A[5] GND 0.60683f
C337 A[4] GND 1.24696f
C338 Y[1] GND 0.38444f
C339 A[11] GND 1.65712f
C340 A[10] GND 1.0665f
C341 A[9] GND 0.59245f
C342 A[8] GND 1.21716f
C343 Y[2] GND 5.17893f
C344 Y[3] GND 4.94982f
C345 Y[4] GND 0.54356f
C346 A[15] GND 1.73764f
C347 A[14] GND 1.30739f
C348 A[13] GND 0.70922f
C349 A[12] GND 1.26335f
C350 VDD GND 49.99955f
C351 x4.x8.X GND 0.35372f
C352 x4.x7.X GND 0.32405f
C353 x4.x6.Y GND 0.29721f
C354 x4.x5.Y GND 0.34625f
C355 x4.x3.X GND 0.22242f
C356 x4.x2.Y GND 0.26638f
C357 a_3281_n4977# GND 0.22645f
C358 a_2830_n4755# GND 0.20356f
C359 a_2361_n4977# GND 0.22969f
C360 a_1349_n4977# GND 0.20085f
C361 a_898_n4755# GND 0.19657f
C362 a_2799_n4163# GND 0.32128f
C363 a_1971_n4163# GND 0.25619f
C364 x4.Z[0] GND 1.12077f
C365 a_1143_n4163# GND 0.25039f
C366 x16.X GND 1.00547f
C367 x17.X GND 0.25942f
C368 a_2370_n3985# GND 0.25905f
C369 a_1542_n3985# GND 0.22802f
C370 a_714_n3985# GND 0.25581f
C371 x17.A0 GND 0.83657f
C372 x3.x8.X GND 0.34708f
C373 x3.x7.X GND 0.32163f
C374 x3.x6.Y GND 0.29459f
C375 x3.x5.Y GND 0.3472f
C376 x3.x3.X GND 0.22037f
C377 x3.x2.Y GND 0.26425f
C378 a_3281_n3277# GND 0.22593f
C379 a_2830_n3055# GND 0.20164f
C380 a_2361_n3277# GND 0.22661f
C381 a_1349_n3277# GND 0.19845f
C382 a_898_n3055# GND 0.19351f
C383 a_2799_n2463# GND 0.32043f
C384 a_1971_n2463# GND 0.26949f
C385 x4.Z[1] GND 1.53855f
C386 x3.Z[1] GND 1.13793f
C387 a_1143_n2463# GND 0.2508f
C388 x13.X GND 0.33758f
C389 x14.X GND 0.47596f
C390 a_2370_n2285# GND 0.26032f
C391 a_1542_n2285# GND 0.25032f
C392 a_714_n2285# GND 0.25797f
C393 x16.A1 GND 0.98816f
C394 x2.x8.X GND 0.34763f
C395 x2.x7.X GND 0.32167f
C396 x2.x6.Y GND 0.29578f
C397 x2.x5.Y GND 0.3482f
C398 x13.A1 GND 0.95523f
C399 x2.x3.X GND 0.21989f
C400 x2.x2.Y GND 0.26425f
C401 a_3281_n1577# GND 0.22593f
C402 a_2830_n1355# GND 0.20107f
C403 a_2361_n1577# GND 0.22645f
C404 a_1349_n1577# GND 0.19884f
C405 a_898_n1355# GND 0.19354f
C406 x10.B GND 0.29915f
C407 x11.B GND 0.31014f
C408 x9.Y GND 0.21121f
C409 x8.Y GND 0.67855f
C410 x6.Y GND 0.32765f
C411 a_2949_n699# GND 0.23053f
C412 a_2498_n477# GND 0.21687f
C413 a_2029_n699# GND 0.23232f
C414 a_985_n727# GND 0.2112f
C415 a_65_n727# GND 0.23198f
C416 x4.Z[2] GND 2.32439f
C417 x3.Z[2] GND 1.30064f
C418 x2.Z[2] GND 1.36686f
C419 x16.A0 GND 2.01987f
C420 x1.x8.X GND 0.34831f
C421 x1.x7.X GND 0.32227f
C422 x1.x6.Y GND 0.29675f
C423 x1.x5.Y GND 0.35816f
C424 x13.A0 GND 1.84617f
C425 x1.x3.X GND 0.22022f
C426 x1.x2.Y GND 0.26476f
C427 x5.A GND 1.20752f
C428 a_3281_123# GND 0.22631f
C429 a_2830_345# GND 0.20156f
C430 a_2361_123# GND 0.22813f
C431 a_1349_123# GND 0.19981f
C432 a_898_345# GND 0.19507f
C433 VDD.t71 GND 0.11263f
C434 VDD.t48 GND 0.1049f
C435 VDD.t42 GND 0.13913f
C436 VDD.t57 GND 0.159f
C437 VDD.t50 GND 0.11428f
C438 VDD.t59 GND 0.10379f
C439 VDD.t137 GND 0.12035f
C440 VDD.t73 GND 0.21421f
C441 VDD.t46 GND 0.19544f
C442 VDD.t52 GND 0.10213f
C443 VDD.t67 GND 0.106f
C444 VDD.t65 GND 0.15182f
C445 VDD.t63 GND 0.15568f
C446 VDD.t25 GND 0.10213f
C447 VDD.t139 GND 0.106f
C448 VDD.t61 GND 0.22059f
C449 VDD.n27 GND 0.21039f
C450 VDD.n38 GND 0.20983f
C451 VDD.t172 GND 0.10379f
C452 VDD.t247 GND 0.1049f
C453 VDD.t218 GND 0.11483f
C454 VDD.t216 GND 0.11649f
C455 VDD.t77 GND 0.15568f
C456 VDD.t82 GND 0.10213f
C457 VDD.t80 GND 0.106f
C458 VDD.t157 GND 0.15182f
C459 VDD.t220 GND 0.15238f
C460 VDD.t175 GND 0.15238f
C461 VDD.t91 GND 0.10213f
C462 VDD.t179 GND 0.106f
C463 VDD.t12 GND 0.15182f
C464 VDD.t0 GND 0.15568f
C465 VDD.t84 GND 0.10213f
C466 VDD.t87 GND 0.106f
C467 VDD.t7 GND 0.22059f
C468 VDD.n47 GND 0.21039f
C469 VDD.t152 GND 0.10379f
C470 VDD.t209 GND 0.1049f
C471 VDD.t241 GND 0.11483f
C472 VDD.t243 GND 0.11649f
C473 VDD.t17 GND 0.15568f
C474 VDD.t21 GND 0.10213f
C475 VDD.t40 GND 0.106f
C476 VDD.t15 GND 0.15182f
C477 VDD.t245 GND 0.15238f
C478 VDD.t153 GND 0.15238f
C479 VDD.t35 GND 0.10213f
C480 VDD.t135 GND 0.106f
C481 VDD.t19 GND 0.15182f
C482 VDD.t31 GND 0.15568f
C483 VDD.t37 GND 0.10213f
C484 VDD.t55 GND 0.106f
C485 VDD.t29 GND 0.22059f
C486 VDD.n128 GND 0.21039f
C487 VDD.n204 GND 0.32002f
C488 VDD.n205 GND 0.4437f
C489 VDD.t222 GND 0.10379f
C490 VDD.t227 GND 0.1049f
C491 VDD.t256 GND 0.11483f
C492 VDD.t258 GND 0.11649f
C493 VDD.t108 GND 0.15568f
C494 VDD.t159 GND 0.10213f
C495 VDD.t4 GND 0.106f
C496 VDD.t111 GND 0.15182f
C497 VDD.t254 GND 0.15238f
C498 VDD.t223 GND 0.15238f
C499 VDD.t145 GND 0.10213f
C500 VDD.t214 GND 0.106f
C501 VDD.t143 GND 0.15182f
C502 VDD.t161 GND 0.15568f
C503 VDD.t9 GND 0.10213f
C504 VDD.t147 GND 0.106f
C505 VDD.t2 GND 0.22059f
C506 VDD.n217 GND 0.21039f
C507 VDD.t236 GND 0.10379f
C508 VDD.t260 GND 0.1049f
C509 VDD.t230 GND 0.11483f
C510 VDD.t232 GND 0.11649f
C511 VDD.t170 GND 0.15568f
C512 VDD.t129 GND 0.10213f
C513 VDD.t127 GND 0.106f
C514 VDD.t168 GND 0.15182f
C515 VDD.t234 GND 0.15238f
C516 VDD.t239 GND 0.15238f
C517 VDD.t181 GND 0.10213f
C518 VDD.t252 GND 0.106f
C519 VDD.t125 GND 0.15182f
C520 VDD.t123 GND 0.15568f
C521 VDD.t117 GND 0.10213f
C522 VDD.t141 GND 0.106f
C523 VDD.t121 GND 0.22059f
C524 VDD.n241 GND 0.21039f
C525 VDD.t197 GND 0.24954f
C526 VDD.t86 GND 0.1579f
C527 VDD.t54 GND 0.17501f
C528 VDD.t187 GND 0.11704f
C529 VDD.t195 GND 0.17115f
C530 VDD.t165 GND 0.1579f
C531 VDD.t11 GND 0.17501f
C532 VDD.t189 GND 0.11704f
C533 VDD.t207 GND 0.17115f
C534 VDD.t149 GND 0.1579f
C535 VDD.t6 GND 0.17501f
C536 VDD.t205 GND 0.11704f
C537 VDD.n343 GND 0.16851f
C538 VDD.n386 GND 0.4439f
C539 VDD.n387 GND 0.20959f
C540 VDD.n447 GND 0.20983f
C541 VDD.t185 GND 0.24954f
C542 VDD.t79 GND 0.1579f
C543 VDD.t39 GND 0.17501f
C544 VDD.t193 GND 0.11704f
C545 VDD.t183 GND 0.17115f
C546 VDD.t105 GND 0.1579f
C547 VDD.t14 GND 0.17501f
C548 VDD.t191 GND 0.11704f
C549 VDD.t203 GND 0.17115f
C550 VDD.t96 GND 0.1579f
C551 VDD.t95 GND 0.17501f
C552 VDD.t201 GND 0.11704f
C553 VDD.n476 GND 0.16851f
C554 VDD.n515 GND 0.21006f
C555 VDD.n516 GND 0.21099f
C556 VDD.n524 GND 0.21076f
C557 VDD.n525 GND 0.32046f
C558 A[12].n0 GND 0.14091f
C559 A[12].n2 GND 0.14558f
C560 A[12].n3 GND 0.1626f
C561 A[12].n4 GND 0.11846f
C562 A[12].n5 GND 0.40766f
C563 A[12].n6 GND 1.72707f
C564 A[13].t1 GND 0.11181f
C565 A[13].n0 GND 0.2102f
C566 A[13].n1 GND 0.23001f
C567 A[13].n2 GND 0.13908f
C568 A[13].n3 GND 0.13375f
C569 A[13].n4 GND 1.83872f
C570 A[13].t5 GND 0.11374f
C571 A[13].n5 GND 0.15916f
C572 A[13].n6 GND 0.31326f
C573 A[14].n0 GND 0.18107f
C574 A[14].n2 GND 0.1884f
C575 A[14].n3 GND 0.89609f
C576 A[14].n4 GND 1.74819f
C577 A[14].n5 GND 0.15126f
C578 A[14].n6 GND 0.20561f
C579 A[15].n0 GND 0.15285f
C580 A[15].n2 GND 0.15346f
C581 A[15].n3 GND 0.13937f
C582 A[15].n4 GND 0.14122f
C583 A[15].n5 GND 0.20479f
C584 A[15].n6 GND 0.97191f
C585 Y[3].n0 GND 0.10527f
C586 Y[3].n4 GND 0.22009f
C587 Y[3].n5 GND 0.22896f
C588 Y[3].n6 GND 0.22009f
C589 Y[3].n8 GND 0.3796f
C590 Y[3].n9 GND 2.73712f
C591 Y[2].n0 GND 0.14101f
C592 Y[2].n1 GND 0.3374f
C593 Y[2].n2 GND 0.2993f
C594 Y[2].t1 GND 0.13781f
C595 Y[2].n7 GND 0.3374f
C596 Y[2].n8 GND 0.14089f
C597 Y[2].n9 GND 0.11618f
C598 Y[2].n10 GND 0.3374f
C599 Y[2].n11 GND 0.14089f
C600 Y[2].n13 GND 1.28022f
C601 Y[2].n14 GND 1.7682f
C602 Y[2].n15 GND 0.3374f
C603 Y[2].n16 GND 0.14089f
C604 Y[2].n18 GND 1.46711f
C605 Y[2].n19 GND 0.28324f
C606 A[8].n0 GND 0.13554f
C607 A[8].n2 GND 0.14003f
C608 A[8].n3 GND 0.1564f
C609 A[8].n4 GND 0.11394f
C610 A[8].n5 GND 0.39212f
C611 A[8].n6 GND 1.66124f
C612 A[9].t1 GND 0.11098f
C613 A[9].n0 GND 0.20864f
C614 A[9].n1 GND 0.2283f
C615 A[9].n2 GND 0.13805f
C616 A[9].n3 GND 0.13276f
C617 A[9].n4 GND 1.82511f
C618 A[9].t5 GND 0.1129f
C619 A[9].n5 GND 0.15798f
C620 A[9].n6 GND 0.31094f
C621 A[10].n0 GND 0.18649f
C622 A[10].n2 GND 0.19404f
C623 A[10].n3 GND 0.92293f
C624 A[10].n4 GND 1.80055f
C625 A[10].t5 GND 0.10032f
C626 A[10].n5 GND 0.15579f
C627 A[10].n6 GND 0.21177f
C628 A[11].n0 GND 0.15066f
C629 A[11].n2 GND 0.15126f
C630 A[11].n3 GND 0.13737f
C631 A[11].n4 GND 0.13919f
C632 A[11].n5 GND 0.20186f
C633 A[11].n6 GND 0.95798f
C634 A[4].n0 GND 0.13438f
C635 A[4].n2 GND 0.13884f
C636 A[4].n3 GND 0.15507f
C637 A[4].n4 GND 0.11297f
C638 A[4].n5 GND 0.38877f
C639 A[4].n6 GND 1.64707f
C640 A[5].t1 GND 0.11083f
C641 A[5].n0 GND 0.20837f
C642 A[5].n1 GND 0.22801f
C643 A[5].n2 GND 0.13787f
C644 A[5].n3 GND 0.13259f
C645 A[5].n4 GND 1.82272f
C646 A[5].t5 GND 0.11275f
C647 A[5].n5 GND 0.15777f
C648 A[5].n6 GND 0.31053f
C649 A[6].n0 GND 0.18538f
C650 A[6].n2 GND 0.19288f
C651 A[6].n3 GND 0.91742f
C652 A[6].n4 GND 1.78981f
C653 A[6].n5 GND 0.15486f
C654 A[6].n6 GND 0.21051f
C655 A[7].n0 GND 0.15042f
C656 A[7].n2 GND 0.15101f
C657 A[7].n3 GND 0.13715f
C658 A[7].n4 GND 0.13897f
C659 A[7].n5 GND 0.20153f
C660 A[7].n6 GND 0.95642f
C661 A[0].n0 GND 0.12414f
C662 A[0].n2 GND 0.12825f
C663 A[0].n3 GND 0.14324f
C664 A[0].n4 GND 0.10435f
C665 A[0].n5 GND 0.35913f
C666 A[0].n6 GND 1.52149f
C667 A[1].t1 GND 0.11009f
C668 A[1].n0 GND 0.20697f
C669 A[1].n1 GND 0.22648f
C670 A[1].n2 GND 0.13695f
C671 A[1].n3 GND 0.1317f
C672 A[1].n4 GND 1.81053f
C673 A[1].t5 GND 0.112f
C674 A[1].n5 GND 0.15672f
C675 A[1].n6 GND 0.30846f
C676 A[2].n0 GND 0.18216f
C677 A[2].n2 GND 0.18954f
C678 A[2].n3 GND 0.9015f
C679 A[2].n4 GND 1.75874f
C680 A[2].n5 GND 0.15217f
C681 A[2].n6 GND 0.20685f
C682 A[3].n0 GND 0.14782f
C683 A[3].n2 GND 0.1484f
C684 A[3].n3 GND 0.13478f
C685 A[3].n4 GND 0.13656f
C686 A[3].n5 GND 0.19805f
C687 A[3].n6 GND 0.93989f
.ends
