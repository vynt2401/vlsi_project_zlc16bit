* NGSPICE file created from adder_1bit.ext - technology: sky130A

.subckt sky130_fd_sc_hd__nand2_1 A B VGND VNB VPB VPWR Y
X0 VPWR A Y VPB sky130_fd_pr__pfet_01v8_hvt ad=0.26 pd=2.52 as=0.135 ps=1.27 w=1 l=0.15
X1 Y A a_113_47# VNB sky130_fd_pr__nfet_01v8 ad=0.169 pd=1.82 as=0.08775 ps=0.92 w=0.65 l=0.15
X2 a_113_47# B VGND VNB sky130_fd_pr__nfet_01v8 ad=0.08775 pd=0.92 as=0.169 ps=1.82 w=0.65 l=0.15
X3 Y B VPWR VPB sky130_fd_pr__pfet_01v8_hvt ad=0.135 pd=1.27 as=0.26 ps=2.52 w=1 l=0.15
.ends

.subckt adder_1bit A B Cin Cout Sum VDD GND
Xx1 A B GND GND VDD VDD x9/A sky130_fd_sc_hd__nand2_1
Xx3 x9/A B GND GND VDD VDD x4/B sky130_fd_sc_hd__nand2_1
Xx2 A x9/A GND GND VDD VDD x4/A sky130_fd_sc_hd__nand2_1
Xx4 x4/A x4/B GND GND VDD VDD x6/A sky130_fd_sc_hd__nand2_1
Xx5 x6/A Cin GND GND VDD VDD x9/B sky130_fd_sc_hd__nand2_1
Xx6 x6/A x9/B GND GND VDD VDD x8/A sky130_fd_sc_hd__nand2_1
Xx7 x9/B Cin GND GND VDD VDD x8/B sky130_fd_sc_hd__nand2_1
Xx8 x8/A x8/B GND GND VDD VDD Sum sky130_fd_sc_hd__nand2_1
Xx9 x9/A x9/B GND GND VDD VDD Cout sky130_fd_sc_hd__nand2_1
.ends
