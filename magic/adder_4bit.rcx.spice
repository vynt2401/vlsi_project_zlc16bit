* NGSPICE file created from adder_4bit.ext - technology: sky130A

.subckt adder_4bit Cin Cout VDD GND A[0] B[0] A[2] B[2] B[1] A[1] Sum[2] B[3] A[3]
+ Sum[0] Sum[1] Sum[3]
X0 a_985_2015# x1.x3.Y GND.t66 GND.t65 sky130_fd_pr__nfet_01v8 ad=0.08775 pd=0.92 as=0.169 ps=1.82 w=0.65 l=0.15
X1 a_1813_735# x3.Cin GND.t83 GND.t82 sky130_fd_pr__nfet_01v8 ad=0.08775 pd=0.92 as=0.169 ps=1.82 w=0.65 l=0.15
X2 VDD.t1 x1.x2.Y x1.x4.Y VDD.t0 sky130_fd_pr__pfet_01v8_hvt ad=0.26 pd=2.52 as=0.135 ps=1.27 w=1 l=0.15
X3 GND.t52 x2.Cin a_1343_1695# GND.t51 sky130_fd_pr__nfet_01v8 ad=0.169 pd=1.82 as=0.08775 ps=0.92 w=0.65 l=0.15
X4 x4.x6.Y x4.x4.Y VDD.t55 VDD.t54 sky130_fd_pr__pfet_01v8_hvt ad=0.135 pd=1.27 as=0.26 ps=2.52 w=1 l=0.15
X5 GND.t103 B[3].t3 a_1895_415# GND.t102 sky130_fd_pr__nfet_01v8 ad=0.169 pd=1.82 as=0.08775 ps=0.92 w=0.65 l=0.15
X6 x1.x1.Y B[0].t3 VDD.t105 VDD.t104 sky130_fd_pr__pfet_01v8_hvt ad=0.135 pd=1.27 as=0.26 ps=2.52 w=1 l=0.15
X7 a_515_1695# x2.x6.Y Sum[1].t2 GND.t67 sky130_fd_pr__nfet_01v8 ad=0.08775 pd=0.92 as=0.169 ps=1.82 w=0.65 l=0.15
X8 VDD.t61 x1.x4.Y x1.x6.Y VDD.t60 sky130_fd_pr__pfet_01v8_hvt ad=0.26 pd=2.52 as=0.135 ps=1.27 w=1 l=0.15
X9 x4.x5.Y x4.x4.Y VDD.t57 VDD.t56 sky130_fd_pr__pfet_01v8_hvt ad=0.135 pd=1.27 as=0.26 ps=2.52 w=1 l=0.15
X10 a_239_415# x4.x1.Y Cout.t2 GND.t37 sky130_fd_pr__nfet_01v8 ad=0.08775 pd=0.92 as=0.169 ps=1.82 w=0.65 l=0.15
X11 VDD.t33 x3.x4.Y x3.x5.Y VDD.t32 sky130_fd_pr__pfet_01v8_hvt ad=0.26 pd=2.52 as=0.135 ps=1.27 w=1 l=0.15
X12 x3.x6.Y x3.x5.Y VDD.t29 VDD.t28 sky130_fd_pr__pfet_01v8_hvt ad=0.135 pd=1.27 as=0.26 ps=2.52 w=1 l=0.15
X13 VDD.t119 B[1].t0 x2.x1.Y VDD.t118 sky130_fd_pr__pfet_01v8_hvt ad=0.26 pd=2.52 as=0.135 ps=1.27 w=1 l=0.15
X14 a_2447_1695# A[1].t2 x2.x1.Y GND.t91 sky130_fd_pr__nfet_01v8 ad=0.08775 pd=0.92 as=0.169 ps=1.82 w=0.65 l=0.15
X15 GND.t46 x4.x3.Y a_1619_415# GND.t45 sky130_fd_pr__nfet_01v8 ad=0.169 pd=1.82 as=0.08775 ps=0.92 w=0.65 l=0.15
X16 a_709_2015# B[0].t0 GND.t76 GND.t75 sky130_fd_pr__nfet_01v8 ad=0.08775 pd=0.92 as=0.169 ps=1.82 w=0.65 l=0.15
X17 VDD.t53 x4.x1.Y x4.x2.Y VDD.t52 sky130_fd_pr__pfet_01v8_hvt ad=0.26 pd=2.52 as=0.135 ps=1.27 w=1 l=0.15
X18 a_1895_415# x4.x1.Y x4.x3.Y GND.t38 sky130_fd_pr__nfet_01v8 ad=0.08775 pd=0.92 as=0.169 ps=1.82 w=0.65 l=0.15
X19 VDD.t139 B[3].t0 x4.x1.Y VDD.t138 sky130_fd_pr__pfet_01v8_hvt ad=0.26 pd=2.52 as=0.135 ps=1.27 w=1 l=0.15
X20 x3.x5.Y x3.Cin VDD.t111 VDD.t110 sky130_fd_pr__pfet_01v8_hvt ad=0.135 pd=1.27 as=0.26 ps=2.52 w=1 l=0.15
X21 VDD.t43 x3.x1.Y x3.x3.Y VDD.t42 sky130_fd_pr__pfet_01v8_hvt ad=0.26 pd=2.52 as=0.135 ps=1.27 w=1 l=0.15
X22 GND.t63 x2.x5.Y a_1067_1695# GND.t62 sky130_fd_pr__nfet_01v8 ad=0.169 pd=1.82 as=0.08775 ps=0.92 w=0.65 l=0.15
X23 x3.x4.Y x3.x3.Y VDD.t39 VDD.t38 sky130_fd_pr__pfet_01v8_hvt ad=0.135 pd=1.27 as=0.26 ps=2.52 w=1 l=0.15
X24 VDD.t85 x2.x5.Y x3.Cin VDD.t84 sky130_fd_pr__pfet_01v8_hvt ad=0.26 pd=2.52 as=0.135 ps=1.27 w=1 l=0.15
X25 VDD.t37 x3.x2.Y x3.x4.Y VDD.t36 sky130_fd_pr__pfet_01v8_hvt ad=0.26 pd=2.52 as=0.135 ps=1.27 w=1 l=0.15
X26 VDD.t9 x2.x1.Y x2.x2.Y VDD.t8 sky130_fd_pr__pfet_01v8_hvt ad=0.26 pd=2.52 as=0.135 ps=1.27 w=1 l=0.15
X27 x1.x5.Y x1.x4.Y a_1261_2015# GND.t43 sky130_fd_pr__nfet_01v8 ad=0.169 pd=1.82 as=0.08775 ps=0.92 w=0.65 l=0.15
X28 GND.t69 x4.Cin a_1343_415# GND.t68 sky130_fd_pr__nfet_01v8 ad=0.169 pd=1.82 as=0.08775 ps=0.92 w=0.65 l=0.15
X29 x1.x6.Y x1.x5.Y VDD.t15 VDD.t14 sky130_fd_pr__pfet_01v8_hvt ad=0.135 pd=1.27 as=0.26 ps=2.52 w=1 l=0.15
X30 Sum[0].t1 x1.x6.Y a_2089_2015# GND.t64 sky130_fd_pr__nfet_01v8 ad=0.169 pd=1.82 as=0.08775 ps=0.92 w=0.65 l=0.15
X31 x2.Cin x1.x5.Y VDD.t17 VDD.t16 sky130_fd_pr__pfet_01v8_hvt ad=0.135 pd=1.27 as=0.26 ps=2.52 w=1 l=0.15
X32 a_1619_415# x4.x2.Y x4.x4.Y GND.t55 sky130_fd_pr__nfet_01v8 ad=0.08775 pd=0.92 as=0.169 ps=1.82 w=0.65 l=0.15
X33 a_1895_1695# x2.x1.Y x2.x3.Y GND.t4 sky130_fd_pr__nfet_01v8 ad=0.08775 pd=0.92 as=0.169 ps=1.82 w=0.65 l=0.15
X34 a_433_2015# x1.x1.Y GND.t48 GND.t47 sky130_fd_pr__nfet_01v8 ad=0.08775 pd=0.92 as=0.169 ps=1.82 w=0.65 l=0.15
X35 VDD.t45 x3.x1.Y x4.Cin VDD.t44 sky130_fd_pr__pfet_01v8_hvt ad=0.26 pd=2.52 as=0.135 ps=1.27 w=1 l=0.15
X36 VDD.t141 A[2].t2 x3.x2.Y VDD.t140 sky130_fd_pr__pfet_01v8_hvt ad=0.26 pd=2.52 as=0.135 ps=1.27 w=1 l=0.15
X37 x3.x3.Y B[2].t2 VDD.t125 VDD.t124 sky130_fd_pr__pfet_01v8_hvt ad=0.135 pd=1.27 as=0.26 ps=2.52 w=1 l=0.15
X38 GND.t54 x2.Cin a_791_1695# GND.t53 sky130_fd_pr__nfet_01v8 ad=0.169 pd=1.82 as=0.08775 ps=0.92 w=0.65 l=0.15
X39 VDD.t99 x3.x6.Y Sum[2].t1 VDD.t98 sky130_fd_pr__pfet_01v8_hvt ad=0.26 pd=2.52 as=0.135 ps=1.27 w=1 l=0.15
X40 x1.x4.Y x1.x2.Y a_985_2015# GND.t0 sky130_fd_pr__nfet_01v8 ad=0.169 pd=1.82 as=0.08775 ps=0.92 w=0.65 l=0.15
X41 x4.Cin x3.x5.Y VDD.t31 VDD.t30 sky130_fd_pr__pfet_01v8_hvt ad=0.135 pd=1.27 as=0.26 ps=2.52 w=1 l=0.15
X42 x3.Cin x2.x1.Y VDD.t7 VDD.t6 sky130_fd_pr__pfet_01v8_hvt ad=0.135 pd=1.27 as=0.26 ps=2.52 w=1 l=0.15
X43 VDD.t3 x2.x3.Y x2.x4.Y VDD.t2 sky130_fd_pr__pfet_01v8_hvt ad=0.26 pd=2.52 as=0.135 ps=1.27 w=1 l=0.15
X44 Sum[0].t0 x1.x7.Y VDD.t11 VDD.t10 sky130_fd_pr__pfet_01v8_hvt ad=0.135 pd=1.27 as=0.26 ps=2.52 w=1 l=0.15
X45 a_1619_1695# x2.x2.Y x2.x4.Y GND.t56 sky130_fd_pr__nfet_01v8 ad=0.08775 pd=0.92 as=0.169 ps=1.82 w=0.65 l=0.15
X46 a_157_2015# B[0].t1 GND.t78 GND.t77 sky130_fd_pr__nfet_01v8 ad=0.08775 pd=0.92 as=0.169 ps=1.82 w=0.65 l=0.15
X47 VDD.t95 x4.Cin x4.x5.Y VDD.t94 sky130_fd_pr__pfet_01v8_hvt ad=0.26 pd=2.52 as=0.135 ps=1.27 w=1 l=0.15
X48 x1.x6.Y x1.x4.Y a_1537_2015# GND.t44 sky130_fd_pr__nfet_01v8 ad=0.169 pd=1.82 as=0.08775 ps=0.92 w=0.65 l=0.15
X49 x2.x7.Y x2.x5.Y VDD.t83 VDD.t82 sky130_fd_pr__pfet_01v8_hvt ad=0.135 pd=1.27 as=0.26 ps=2.52 w=1 l=0.15
X50 x4.x1.Y A[3].t0 VDD.t129 VDD.t128 sky130_fd_pr__pfet_01v8_hvt ad=0.135 pd=1.27 as=0.26 ps=2.52 w=1 l=0.15
X51 VDD.t63 x4.x3.Y x4.x4.Y VDD.t62 sky130_fd_pr__pfet_01v8_hvt ad=0.26 pd=2.52 as=0.135 ps=1.27 w=1 l=0.15
X52 x3.x5.Y x3.x4.Y a_1261_735# GND.t26 sky130_fd_pr__nfet_01v8 ad=0.169 pd=1.82 as=0.08775 ps=0.92 w=0.65 l=0.15
X53 x1.x7.Y Cin.t2 VDD.t133 VDD.t132 sky130_fd_pr__pfet_01v8_hvt ad=0.135 pd=1.27 as=0.26 ps=2.52 w=1 l=0.15
X54 a_1537_735# x3.x5.Y GND.t22 GND.t21 sky130_fd_pr__nfet_01v8 ad=0.08775 pd=0.92 as=0.169 ps=1.82 w=0.65 l=0.15
X55 GND.t15 x2.x7.Y a_515_1695# GND.t14 sky130_fd_pr__nfet_01v8 ad=0.169 pd=1.82 as=0.08775 ps=0.92 w=0.65 l=0.15
X56 VDD.t23 x4.x5.Y Cout.t0 VDD.t22 sky130_fd_pr__pfet_01v8_hvt ad=0.26 pd=2.52 as=0.135 ps=1.27 w=1 l=0.15
X57 Sum[2].t0 x3.x7.Y VDD.t47 VDD.t46 sky130_fd_pr__pfet_01v8_hvt ad=0.135 pd=1.27 as=0.26 ps=2.52 w=1 l=0.15
X58 VDD.t69 x1.x1.Y x1.x3.Y VDD.t68 sky130_fd_pr__pfet_01v8_hvt ad=0.26 pd=2.52 as=0.135 ps=1.27 w=1 l=0.15
X59 a_1261_735# x3.Cin GND.t81 GND.t80 sky130_fd_pr__nfet_01v8 ad=0.08775 pd=0.92 as=0.169 ps=1.82 w=0.65 l=0.15
X60 x3.x3.Y x3.x1.Y a_709_735# GND.t33 sky130_fd_pr__nfet_01v8 ad=0.169 pd=1.82 as=0.08775 ps=0.92 w=0.65 l=0.15
X61 VDD.t73 x2.Cin x2.x5.Y VDD.t72 sky130_fd_pr__pfet_01v8_hvt ad=0.26 pd=2.52 as=0.135 ps=1.27 w=1 l=0.15
X62 a_985_735# x3.x3.Y GND.t30 GND.t29 sky130_fd_pr__nfet_01v8 ad=0.08775 pd=0.92 as=0.169 ps=1.82 w=0.65 l=0.15
X63 a_1343_1695# x2.x4.Y x2.x5.Y GND.t58 sky130_fd_pr__nfet_01v8 ad=0.08775 pd=0.92 as=0.169 ps=1.82 w=0.65 l=0.15
X64 x3.x4.Y x3.x2.Y a_985_735# GND.t28 sky130_fd_pr__nfet_01v8 ad=0.169 pd=1.82 as=0.08775 ps=0.92 w=0.65 l=0.15
X65 Sum[1].t1 x2.x6.Y VDD.t93 VDD.t92 sky130_fd_pr__pfet_01v8_hvt ad=0.135 pd=1.27 as=0.26 ps=2.52 w=1 l=0.15
X66 a_2171_1695# A[1].t3 x2.x2.Y GND.t90 sky130_fd_pr__nfet_01v8 ad=0.08775 pd=0.92 as=0.169 ps=1.82 w=0.65 l=0.15
X67 x2.x1.Y A[1].t0 VDD.t121 VDD.t120 sky130_fd_pr__pfet_01v8_hvt ad=0.135 pd=1.27 as=0.26 ps=2.52 w=1 l=0.15
X68 a_1537_2015# x1.x5.Y GND.t10 GND.t9 sky130_fd_pr__nfet_01v8 ad=0.08775 pd=0.92 as=0.169 ps=1.82 w=0.65 l=0.15
X69 VDD.t101 A[0].t2 x1.x2.Y VDD.t100 sky130_fd_pr__pfet_01v8_hvt ad=0.26 pd=2.52 as=0.135 ps=1.27 w=1 l=0.15
X70 a_2365_2015# x1.x5.Y GND.t13 GND.t12 sky130_fd_pr__nfet_01v8 ad=0.08775 pd=0.92 as=0.169 ps=1.82 w=0.65 l=0.15
X71 GND.t20 x4.x5.Y a_1067_415# GND.t19 sky130_fd_pr__nfet_01v8 ad=0.169 pd=1.82 as=0.08775 ps=0.92 w=0.65 l=0.15
X72 x4.Cin x3.x1.Y a_2365_735# GND.t34 sky130_fd_pr__nfet_01v8 ad=0.169 pd=1.82 as=0.08775 ps=0.92 w=0.65 l=0.15
X73 x3.x2.Y A[2].t0 a_433_735# GND.t107 sky130_fd_pr__nfet_01v8 ad=0.169 pd=1.82 as=0.08775 ps=0.92 w=0.65 l=0.15
X74 a_1343_415# x4.x4.Y x4.x5.Y GND.t42 sky130_fd_pr__nfet_01v8 ad=0.08775 pd=0.92 as=0.169 ps=1.82 w=0.65 l=0.15
X75 GND.t71 x4.Cin a_791_415# GND.t70 sky130_fd_pr__nfet_01v8 ad=0.169 pd=1.82 as=0.08775 ps=0.92 w=0.65 l=0.15
X76 a_709_735# B[2].t0 GND.t93 GND.t92 sky130_fd_pr__nfet_01v8 ad=0.08775 pd=0.92 as=0.169 ps=1.82 w=0.65 l=0.15
X77 VDD.t87 x2.x5.Y x2.x6.Y VDD.t86 sky130_fd_pr__pfet_01v8_hvt ad=0.26 pd=2.52 as=0.135 ps=1.27 w=1 l=0.15
X78 a_1067_1695# x2.x4.Y x2.x6.Y GND.t57 sky130_fd_pr__nfet_01v8 ad=0.08775 pd=0.92 as=0.169 ps=1.82 w=0.65 l=0.15
X79 VDD.t67 x1.x1.Y x2.Cin VDD.t66 sky130_fd_pr__pfet_01v8_hvt ad=0.26 pd=2.52 as=0.135 ps=1.27 w=1 l=0.15
X80 VDD.t143 A[2].t3 x3.x1.Y VDD.t142 sky130_fd_pr__pfet_01v8_hvt ad=0.26 pd=2.52 as=0.135 ps=1.27 w=1 l=0.15
X81 GND.t87 B[1].t3 a_1895_1695# GND.t86 sky130_fd_pr__nfet_01v8 ad=0.169 pd=1.82 as=0.08775 ps=0.92 w=0.65 l=0.15
X82 x3.x2.Y x3.x1.Y VDD.t41 VDD.t40 sky130_fd_pr__pfet_01v8_hvt ad=0.135 pd=1.27 as=0.26 ps=2.52 w=1 l=0.15
X83 x1.x5.Y Cin.t3 VDD.t135 VDD.t134 sky130_fd_pr__pfet_01v8_hvt ad=0.135 pd=1.27 as=0.26 ps=2.52 w=1 l=0.15
X84 x4.x4.Y x4.x2.Y VDD.t75 VDD.t74 sky130_fd_pr__pfet_01v8_hvt ad=0.135 pd=1.27 as=0.26 ps=2.52 w=1 l=0.15
X85 Cout.t1 x4.x1.Y VDD.t51 VDD.t50 sky130_fd_pr__pfet_01v8_hvt ad=0.135 pd=1.27 as=0.26 ps=2.52 w=1 l=0.15
X86 Sum[2].t2 x3.x6.Y a_2089_735# GND.t72 sky130_fd_pr__nfet_01v8 ad=0.169 pd=1.82 as=0.08775 ps=0.92 w=0.65 l=0.15
X87 x4.x3.Y x4.x1.Y VDD.t49 VDD.t48 sky130_fd_pr__pfet_01v8_hvt ad=0.135 pd=1.27 as=0.26 ps=2.52 w=1 l=0.15
X88 GND.t105 B[3].t2 a_2447_415# GND.t104 sky130_fd_pr__nfet_01v8 ad=0.169 pd=1.82 as=0.08775 ps=0.92 w=0.65 l=0.15
X89 a_2365_735# x3.x5.Y GND.t25 GND.t24 sky130_fd_pr__nfet_01v8 ad=0.08775 pd=0.92 as=0.169 ps=1.82 w=0.65 l=0.15
X90 a_791_415# x4.x5.Y x4.x7.Y GND.t18 sky130_fd_pr__nfet_01v8 ad=0.08775 pd=0.92 as=0.169 ps=1.82 w=0.65 l=0.15
X91 a_2089_2015# x1.x7.Y GND.t8 GND.t7 sky130_fd_pr__nfet_01v8 ad=0.08775 pd=0.92 as=0.169 ps=1.82 w=0.65 l=0.15
X92 x2.x3.Y x2.x1.Y VDD.t5 VDD.t4 sky130_fd_pr__pfet_01v8_hvt ad=0.135 pd=1.27 as=0.26 ps=2.52 w=1 l=0.15
X93 VDD.t103 A[0].t3 x1.x1.Y VDD.t102 sky130_fd_pr__pfet_01v8_hvt ad=0.26 pd=2.52 as=0.135 ps=1.27 w=1 l=0.15
X94 Sum[3].t1 x4.x6.Y VDD.t109 VDD.t108 sky130_fd_pr__pfet_01v8_hvt ad=0.135 pd=1.27 as=0.26 ps=2.52 w=1 l=0.15
X95 a_1067_415# x4.x4.Y x4.x6.Y GND.t41 sky130_fd_pr__nfet_01v8 ad=0.08775 pd=0.92 as=0.169 ps=1.82 w=0.65 l=0.15
X96 GND.t85 x4.x7.Y a_515_415# GND.t84 sky130_fd_pr__nfet_01v8 ad=0.169 pd=1.82 as=0.08775 ps=0.92 w=0.65 l=0.15
X97 VDD.t27 x3.x5.Y x3.x7.Y VDD.t26 sky130_fd_pr__pfet_01v8_hvt ad=0.26 pd=2.52 as=0.135 ps=1.27 w=1 l=0.15
X98 a_1813_2015# Cin.t0 GND.t101 GND.t100 sky130_fd_pr__nfet_01v8 ad=0.08775 pd=0.92 as=0.169 ps=1.82 w=0.65 l=0.15
X99 x4.x7.Y x4.x5.Y VDD.t21 VDD.t20 sky130_fd_pr__pfet_01v8_hvt ad=0.135 pd=1.27 as=0.26 ps=2.52 w=1 l=0.15
X100 x3.x1.Y B[2].t3 VDD.t127 VDD.t126 sky130_fd_pr__pfet_01v8_hvt ad=0.135 pd=1.27 as=0.26 ps=2.52 w=1 l=0.15
X101 VDD.t71 x2.Cin x2.x7.Y VDD.t70 sky130_fd_pr__pfet_01v8_hvt ad=0.26 pd=2.52 as=0.135 ps=1.27 w=1 l=0.15
X102 GND.t89 B[1].t2 a_2447_1695# GND.t88 sky130_fd_pr__nfet_01v8 ad=0.169 pd=1.82 as=0.08775 ps=0.92 w=0.65 l=0.15
X103 VDD.t13 x1.x5.Y x1.x7.Y VDD.t12 sky130_fd_pr__pfet_01v8_hvt ad=0.26 pd=2.52 as=0.135 ps=1.27 w=1 l=0.15
X104 GND.t40 x4.x1.Y a_2171_415# GND.t39 sky130_fd_pr__nfet_01v8 ad=0.169 pd=1.82 as=0.08775 ps=0.92 w=0.65 l=0.15
X105 GND.t17 x4.x5.Y a_239_415# GND.t16 sky130_fd_pr__nfet_01v8 ad=0.169 pd=1.82 as=0.08775 ps=0.92 w=0.65 l=0.15
X106 a_2089_735# x3.x7.Y GND.t36 GND.t35 sky130_fd_pr__nfet_01v8 ad=0.08775 pd=0.92 as=0.169 ps=1.82 w=0.65 l=0.15
X107 x1.x3.Y x1.x1.Y a_709_2015# GND.t49 sky130_fd_pr__nfet_01v8 ad=0.169 pd=1.82 as=0.08775 ps=0.92 w=0.65 l=0.15
X108 a_2447_415# A[3].t2 x4.x1.Y GND.t97 sky130_fd_pr__nfet_01v8 ad=0.08775 pd=0.92 as=0.169 ps=1.82 w=0.65 l=0.15
X109 VDD.t35 x3.x4.Y x3.x6.Y VDD.t34 sky130_fd_pr__pfet_01v8_hvt ad=0.26 pd=2.52 as=0.135 ps=1.27 w=1 l=0.15
X110 x1.x4.Y x1.x3.Y VDD.t91 VDD.t90 sky130_fd_pr__pfet_01v8_hvt ad=0.135 pd=1.27 as=0.26 ps=2.52 w=1 l=0.15
X111 a_515_415# x4.x6.Y Sum[3].t0 GND.t79 sky130_fd_pr__nfet_01v8 ad=0.08775 pd=0.92 as=0.169 ps=1.82 w=0.65 l=0.15
X112 x3.x7.Y x3.Cin VDD.t113 VDD.t112 sky130_fd_pr__pfet_01v8_hvt ad=0.135 pd=1.27 as=0.26 ps=2.52 w=1 l=0.15
X113 x2.x4.Y x2.x2.Y VDD.t77 VDD.t76 sky130_fd_pr__pfet_01v8_hvt ad=0.135 pd=1.27 as=0.26 ps=2.52 w=1 l=0.15
X114 GND.t60 x2.x5.Y a_239_1695# GND.t59 sky130_fd_pr__nfet_01v8 ad=0.169 pd=1.82 as=0.08775 ps=0.92 w=0.65 l=0.15
X115 a_2171_415# A[3].t3 x4.x2.Y GND.t96 sky130_fd_pr__nfet_01v8 ad=0.08775 pd=0.92 as=0.169 ps=1.82 w=0.65 l=0.15
X116 VDD.t19 x2.x7.Y Sum[1].t0 VDD.t18 sky130_fd_pr__pfet_01v8_hvt ad=0.26 pd=2.52 as=0.135 ps=1.27 w=1 l=0.15
X117 GND.t6 x2.x1.Y a_2171_1695# GND.t5 sky130_fd_pr__nfet_01v8 ad=0.169 pd=1.82 as=0.08775 ps=0.92 w=0.65 l=0.15
X118 x1.x2.Y A[0].t0 a_433_2015# GND.t74 sky130_fd_pr__nfet_01v8 ad=0.169 pd=1.82 as=0.08775 ps=0.92 w=0.65 l=0.15
X119 VDD.t25 x4.x5.Y x4.x6.Y VDD.t24 sky130_fd_pr__pfet_01v8_hvt ad=0.26 pd=2.52 as=0.135 ps=1.27 w=1 l=0.15
X120 x1.x3.Y B[0].t2 VDD.t107 VDD.t106 sky130_fd_pr__pfet_01v8_hvt ad=0.135 pd=1.27 as=0.26 ps=2.52 w=1 l=0.15
X121 VDD.t137 B[3].t1 x4.x3.Y VDD.t136 sky130_fd_pr__pfet_01v8_hvt ad=0.26 pd=2.52 as=0.135 ps=1.27 w=1 l=0.15
X122 x2.Cin x1.x1.Y a_2365_2015# GND.t50 sky130_fd_pr__nfet_01v8 ad=0.169 pd=1.82 as=0.08775 ps=0.92 w=0.65 l=0.15
X123 x3.x1.Y A[2].t1 a_157_735# GND.t106 sky130_fd_pr__nfet_01v8 ad=0.169 pd=1.82 as=0.08775 ps=0.92 w=0.65 l=0.15
X124 x2.x5.Y x2.x4.Y VDD.t81 VDD.t80 sky130_fd_pr__pfet_01v8_hvt ad=0.135 pd=1.27 as=0.26 ps=2.52 w=1 l=0.15
X125 x2.x2.Y A[1].t1 VDD.t123 VDD.t122 sky130_fd_pr__pfet_01v8_hvt ad=0.135 pd=1.27 as=0.26 ps=2.52 w=1 l=0.15
X126 a_433_735# x3.x1.Y GND.t32 GND.t31 sky130_fd_pr__nfet_01v8 ad=0.08775 pd=0.92 as=0.169 ps=1.82 w=0.65 l=0.15
X127 a_1261_2015# Cin.t1 GND.t99 GND.t98 sky130_fd_pr__nfet_01v8 ad=0.08775 pd=0.92 as=0.169 ps=1.82 w=0.65 l=0.15
X128 x4.x2.Y A[3].t1 VDD.t131 VDD.t130 sky130_fd_pr__pfet_01v8_hvt ad=0.135 pd=1.27 as=0.26 ps=2.52 w=1 l=0.15
X129 VDD.t115 x4.x7.Y Sum[3].t2 VDD.t114 sky130_fd_pr__pfet_01v8_hvt ad=0.26 pd=2.52 as=0.135 ps=1.27 w=1 l=0.15
X130 VDD.t97 x4.Cin x4.x7.Y VDD.t96 sky130_fd_pr__pfet_01v8_hvt ad=0.26 pd=2.52 as=0.135 ps=1.27 w=1 l=0.15
X131 a_239_1695# x2.x1.Y x3.Cin GND.t3 sky130_fd_pr__nfet_01v8 ad=0.08775 pd=0.92 as=0.169 ps=1.82 w=0.65 l=0.15
X132 VDD.t59 x1.x4.Y x1.x5.Y VDD.t58 sky130_fd_pr__pfet_01v8_hvt ad=0.26 pd=2.52 as=0.135 ps=1.27 w=1 l=0.15
X133 VDD.t89 x1.x6.Y Sum[0].t2 VDD.t88 sky130_fd_pr__pfet_01v8_hvt ad=0.26 pd=2.52 as=0.135 ps=1.27 w=1 l=0.15
X134 x1.x1.Y A[0].t1 a_157_2015# GND.t73 sky130_fd_pr__nfet_01v8 ad=0.169 pd=1.82 as=0.08775 ps=0.92 w=0.65 l=0.15
X135 GND.t2 x2.x3.Y a_1619_1695# GND.t1 sky130_fd_pr__nfet_01v8 ad=0.169 pd=1.82 as=0.08775 ps=0.92 w=0.65 l=0.15
X136 x3.x7.Y x3.x5.Y a_1813_735# GND.t23 sky130_fd_pr__nfet_01v8 ad=0.169 pd=1.82 as=0.08775 ps=0.92 w=0.65 l=0.15
X137 x1.x2.Y x1.x1.Y VDD.t65 VDD.t64 sky130_fd_pr__pfet_01v8_hvt ad=0.135 pd=1.27 as=0.26 ps=2.52 w=1 l=0.15
X138 a_791_1695# x2.x5.Y x2.x7.Y GND.t61 sky130_fd_pr__nfet_01v8 ad=0.08775 pd=0.92 as=0.169 ps=1.82 w=0.65 l=0.15
X139 VDD.t117 B[1].t1 x2.x3.Y VDD.t116 sky130_fd_pr__pfet_01v8_hvt ad=0.26 pd=2.52 as=0.135 ps=1.27 w=1 l=0.15
X140 x2.x6.Y x2.x4.Y VDD.t79 VDD.t78 sky130_fd_pr__pfet_01v8_hvt ad=0.135 pd=1.27 as=0.26 ps=2.52 w=1 l=0.15
X141 a_157_735# B[2].t1 GND.t95 GND.t94 sky130_fd_pr__nfet_01v8 ad=0.08775 pd=0.92 as=0.169 ps=1.82 w=0.65 l=0.15
X142 x1.x7.Y x1.x5.Y a_1813_2015# GND.t11 sky130_fd_pr__nfet_01v8 ad=0.169 pd=1.82 as=0.08775 ps=0.92 w=0.65 l=0.15
X143 x3.x6.Y x3.x4.Y a_1537_735# GND.t27 sky130_fd_pr__nfet_01v8 ad=0.169 pd=1.82 as=0.08775 ps=0.92 w=0.65 l=0.15
R0 Sum[3].t0 Sum[3].n0 271.668
R1 Sum[3].n3 Sum[3].t0 258.846
R2 Sum[3] Sum[3].n1 224.778
R3 Sum[3].n1 Sum[3].t2 26.5955
R4 Sum[3].n1 Sum[3].t1 26.5955
R5 Sum[3].n0 Sum[3] 11.6358
R6 Sum[3].n2 Sum[3] 3.76521
R7 Sum[3].n3 Sum[3].n2 3.03935
R8 Sum[3] Sum[3].n3 2.30266
R9 Sum[3].n2 Sum[3] 0.921363
R10 Sum[3] Sum[3].n0 0.368845
R11 Cout.n3 Cout.n2 192.982
R12 Cout.n0 Cout.t2 132.067
R13 Cout Cout.n3 31.7962
R14 Cout.n2 Cout.t0 26.5955
R15 Cout.n2 Cout.t1 26.5955
R16 Cout.n3 Cout 20.4254
R17 Cout.n1 Cout.n0 4.15748
R18 Cout Cout.n1 3.76521
R19 Cout.n0 Cout 1.17559
R20 Cout.n1 Cout 0.921363
R21 A[3].n1 A[3].t0 230.155
R22 A[3].n0 A[3].t1 230.155
R23 A[3].n1 A[3].t2 157.856
R24 A[3].n0 A[3].t3 157.856
R25 A[3].n2 A[3].n1 152
R26 A[3].n4 A[3].n0 152
R27 A[3].n4 A[3].n3 10.8525
R28 A[3].n3 A[3].n2 9.62931
R29 A[3].n2 A[3] 6.4005
R30 A[3] A[3].n4 6.4005
R31 A[3].n3 A[3] 1.17014
R32 B[3].n0 B[3].t0 229.369
R33 B[3].n3 B[3].t1 229.369
R34 B[3].n0 B[3].t2 157.07
R35 B[3].n3 B[3].t3 157.07
R36 B[3].n1 B[3].n0 152
R37 B[3].n4 B[3].n3 152
R38 B[3].n4 B[3].n2 21.271
R39 B[3].n2 B[3].n1 9.87363
R40 B[3].n1 B[3] 4.39453
R41 B[3] B[3].n4 4.39453
R42 B[3].n2 B[3] 0.299328
R43 Sum[2] Sum[2].n0 237.577
R44 Sum[2].n1 Sum[2].t2 139.514
R45 Sum[2].n0 Sum[2].t1 26.5955
R46 Sum[2].n0 Sum[2].t0 26.5955
R47 Sum[2].n2 Sum[2] 16.5652
R48 Sum[2].n1 Sum[2] 11.6179
R49 Sum[2].n2 Sum[2] 9.03579
R50 Sum[2] Sum[2].n2 1.72748
R51 Sum[2].n2 Sum[2].n1 1.01637
R52 A[2].n0 A[2].t3 230.155
R53 A[2].n3 A[2].t2 230.155
R54 A[2].n0 A[2].t1 157.856
R55 A[2].n3 A[2].t0 157.856
R56 A[2].n1 A[2].n0 152
R57 A[2].n4 A[2].n3 152
R58 A[2].n4 A[2].n2 11.0436
R59 A[2].n2 A[2].n1 9.82035
R60 A[2].n1 A[2] 2.10199
R61 A[2] A[2].n4 2.10199
R62 A[2].n2 A[2] 1.188
R63 B[2].n1 B[2].t3 229.369
R64 B[2].n0 B[2].t2 229.369
R65 B[2].n1 B[2].t1 157.07
R66 B[2].n0 B[2].t0 157.07
R67 B[2].n2 B[2].n1 154.845
R68 B[2].n4 B[2].n0 152
R69 B[2].n4 B[2].n3 20.6978
R70 B[2].n3 B[2].n2 9.3005
R71 B[2] B[2].n4 5.92643
R72 B[2].n2 B[2] 3.08198
R73 B[2].n3 B[2] 0.317185
R74 Sum[1].t2 Sum[1].n0 271.668
R75 Sum[1].n3 Sum[1].t2 258.846
R76 Sum[1] Sum[1].n1 224.778
R77 Sum[1].n1 Sum[1].t0 26.5955
R78 Sum[1].n1 Sum[1].t1 26.5955
R79 Sum[1].n0 Sum[1] 11.6358
R80 Sum[1].n2 Sum[1] 3.76521
R81 Sum[1].n3 Sum[1].n2 3.03935
R82 Sum[1] Sum[1].n3 2.30266
R83 Sum[1].n2 Sum[1] 0.921363
R84 Sum[1] Sum[1].n0 0.368845
R85 A[1].n1 A[1].t0 230.155
R86 A[1].n0 A[1].t1 230.155
R87 A[1].n1 A[1].t2 157.856
R88 A[1].n0 A[1].t3 157.856
R89 A[1].n2 A[1].n1 152
R90 A[1].n4 A[1].n0 152
R91 A[1].n4 A[1].n3 10.8525
R92 A[1].n3 A[1].n2 9.62931
R93 A[1].n2 A[1] 6.4005
R94 A[1] A[1].n4 6.4005
R95 A[1].n3 A[1] 1.17014
R96 B[1].n0 B[1].t0 229.369
R97 B[1].n3 B[1].t1 229.369
R98 B[1].n0 B[1].t2 157.07
R99 B[1].n3 B[1].t3 157.07
R100 B[1].n1 B[1].n0 152
R101 B[1].n4 B[1].n3 152
R102 B[1].n4 B[1].n2 21.271
R103 B[1].n2 B[1].n1 9.87363
R104 B[1].n1 B[1] 4.39453
R105 B[1] B[1].n4 4.39453
R106 B[1].n2 B[1] 0.299328
R107 Sum[0] Sum[0].n0 237.577
R108 Sum[0].n1 Sum[0].t1 139.514
R109 Sum[0].n0 Sum[0].t2 26.5955
R110 Sum[0].n0 Sum[0].t0 26.5955
R111 Sum[0].n2 Sum[0] 16.5652
R112 Sum[0].n1 Sum[0] 11.6179
R113 Sum[0].n2 Sum[0] 9.03579
R114 Sum[0] Sum[0].n2 1.72748
R115 Sum[0].n2 Sum[0].n1 1.01637
R116 Cin.n1 Cin.t3 229.369
R117 Cin.n0 Cin.t2 229.369
R118 Cin.n1 Cin.t1 157.07
R119 Cin.n0 Cin.t0 157.07
R120 Cin.n2 Cin.n1 152.475
R121 Cin.n4 Cin.n0 152
R122 Cin.n4 Cin.n3 16.115
R123 Cin.n3 Cin.n2 13.8025
R124 Cin.n3 Cin 5.99157
R125 Cin Cin.n4 5.92643
R126 Cin.n2 Cin 5.45235
R127 A[0].n0 A[0].t3 230.155
R128 A[0].n3 A[0].t2 230.155
R129 A[0].n0 A[0].t1 157.856
R130 A[0].n3 A[0].t0 157.856
R131 A[0].n1 A[0].n0 152
R132 A[0].n4 A[0].n3 152
R133 A[0].n4 A[0].n2 11.0436
R134 A[0].n2 A[0].n1 9.82035
R135 A[0].n1 A[0] 2.10199
R136 A[0] A[0].n4 2.10199
R137 A[0].n2 A[0] 1.188
R138 B[0].n1 B[0].t3 229.369
R139 B[0].n0 B[0].t2 229.369
R140 B[0].n1 B[0].t1 157.07
R141 B[0].n0 B[0].t0 157.07
R142 B[0].n2 B[0].n1 154.845
R143 B[0].n4 B[0].n0 152
R144 B[0].n4 B[0].n3 20.6978
R145 B[0].n3 B[0].n2 9.3005
R146 B[0] B[0].n4 5.92643
R147 B[0].n2 B[0] 3.08198
R148 B[0].n3 B[0] 0.317185
R149 VDD.n83 VDD.t66 627.449
R150 VDD.n206 VDD.t50 627.449
R151 VDD VDD.t128 461.683
R152 VDD VDD.t130 461.683
R153 VDD VDD.t48 461.683
R154 VDD VDD.t74 461.683
R155 VDD VDD.t56 461.683
R156 VDD VDD.t54 461.683
R157 VDD VDD.t20 461.683
R158 VDD VDD.t108 461.683
R159 VDD VDD.t88 361.06
R160 VDD VDD.t12 361.06
R161 VDD VDD.t60 361.06
R162 VDD VDD.t58 361.06
R163 VDD VDD.t0 361.06
R164 VDD VDD.t68 361.06
R165 VDD VDD.t100 361.06
R166 VDD VDD.t102 361.06
R167 VDD.n3 VDD.t143 249.363
R168 VDD.n6 VDD.t141 249.363
R169 VDD.n112 VDD.t43 249.363
R170 VDD.n46 VDD.t37 249.363
R171 VDD.n42 VDD.t33 249.363
R172 VDD.n38 VDD.t35 249.363
R173 VDD.n37 VDD.t27 249.363
R174 VDD.n161 VDD.t99 249.363
R175 VDD.n1 VDD.t45 249.363
R176 VDD.n57 VDD.t103 249.363
R177 VDD.n62 VDD.t101 249.363
R178 VDD.n49 VDD.t69 249.363
R179 VDD.n105 VDD.t1 249.363
R180 VDD.n71 VDD.t59 249.363
R181 VDD.n97 VDD.t61 249.363
R182 VDD.n78 VDD.t13 249.363
R183 VDD.n89 VDD.t89 249.363
R184 VDD.n82 VDD.t67 249.363
R185 VDD.n156 VDD.t121 249.362
R186 VDD.n153 VDD.t123 249.362
R187 VDD.n32 VDD.t5 249.362
R188 VDD.n39 VDD.t77 249.362
R189 VDD.n43 VDD.t81 249.362
R190 VDD.n47 VDD.t79 249.362
R191 VDD.n8 VDD.t83 249.362
R192 VDD.n5 VDD.t93 249.362
R193 VDD.n2 VDD.t7 249.362
R194 VDD.n166 VDD.t129 249.362
R195 VDD.n19 VDD.t131 249.362
R196 VDD.n18 VDD.t49 249.362
R197 VDD.n16 VDD.t75 249.362
R198 VDD.n15 VDD.t57 249.362
R199 VDD.n13 VDD.t55 249.362
R200 VDD.n12 VDD.t21 249.362
R201 VDD.n212 VDD.t109 249.362
R202 VDD.n205 VDD.t51 249.362
R203 VDD.t66 VDD.t16 248.599
R204 VDD.t88 VDD.t10 248.599
R205 VDD.t12 VDD.t132 248.599
R206 VDD.t60 VDD.t14 248.599
R207 VDD.t58 VDD.t134 248.599
R208 VDD.t0 VDD.t90 248.599
R209 VDD.t68 VDD.t106 248.599
R210 VDD.t100 VDD.t64 248.599
R211 VDD.t102 VDD.t104 248.599
R212 VDD.t128 VDD.t138 248.599
R213 VDD.t130 VDD.t52 248.599
R214 VDD.t48 VDD.t136 248.599
R215 VDD.t74 VDD.t62 248.599
R216 VDD.t56 VDD.t94 248.599
R217 VDD.t54 VDD.t24 248.599
R218 VDD.t20 VDD.t96 248.599
R219 VDD.t108 VDD.t114 248.599
R220 VDD.t50 VDD.t22 248.599
R221 VDD.n234 VDD.t127 247.394
R222 VDD.n225 VDD.t41 247.394
R223 VDD.n115 VDD.t125 247.394
R224 VDD.n123 VDD.t39 247.394
R225 VDD.n131 VDD.t111 247.394
R226 VDD.n139 VDD.t29 247.394
R227 VDD.n147 VDD.t113 247.394
R228 VDD.n36 VDD.t47 247.394
R229 VDD.n160 VDD.t31 247.394
R230 VDD.n58 VDD.t65 247.394
R231 VDD.n63 VDD.t107 247.394
R232 VDD.n68 VDD.t91 247.394
R233 VDD.n104 VDD.t135 247.394
R234 VDD.n99 VDD.t15 247.394
R235 VDD.n96 VDD.t133 247.394
R236 VDD.n91 VDD.t11 247.394
R237 VDD.n88 VDD.t17 247.394
R238 VDD.n26 VDD.t119 247.394
R239 VDD.n155 VDD.t9 247.394
R240 VDD.n152 VDD.t117 247.394
R241 VDD.n144 VDD.t3 247.394
R242 VDD.n136 VDD.t73 247.394
R243 VDD.n128 VDD.t87 247.394
R244 VDD.n120 VDD.t71 247.394
R245 VDD.n219 VDD.t19 247.394
R246 VDD.n228 VDD.t85 247.394
R247 VDD.n168 VDD.t139 247.394
R248 VDD.n173 VDD.t53 247.394
R249 VDD.n178 VDD.t137 247.394
R250 VDD.n183 VDD.t63 247.394
R251 VDD.n188 VDD.t95 247.394
R252 VDD.n193 VDD.t25 247.394
R253 VDD.n198 VDD.t97 247.394
R254 VDD.n203 VDD.t115 247.394
R255 VDD.n211 VDD.t23 247.394
R256 VDD.n53 VDD.t105 247.393
R257 VDD.n239 VDD 244.69
R258 VDD.n238 VDD.n237 213.119
R259 VDD.t16 VDD 207.166
R260 VDD.t10 VDD 207.166
R261 VDD.t132 VDD 207.166
R262 VDD.t14 VDD 207.166
R263 VDD.t134 VDD 207.166
R264 VDD.t90 VDD 207.166
R265 VDD.t106 VDD 207.166
R266 VDD.t64 VDD 207.166
R267 VDD.t104 VDD 207.166
R268 VDD.t118 VDD.t44 117.674
R269 VDD.t120 VDD.t30 117.674
R270 VDD.t8 VDD.t98 117.674
R271 VDD.t122 VDD.t46 117.674
R272 VDD.t116 VDD.t26 117.674
R273 VDD.t4 VDD.t112 117.674
R274 VDD.t2 VDD.t34 117.674
R275 VDD.t76 VDD.t28 117.674
R276 VDD.t72 VDD.t32 117.674
R277 VDD.t80 VDD.t110 117.674
R278 VDD.t86 VDD.t36 117.674
R279 VDD.t78 VDD.t38 117.674
R280 VDD.t70 VDD.t42 117.674
R281 VDD.t82 VDD.t124 117.674
R282 VDD.t18 VDD.t140 117.674
R283 VDD.t92 VDD.t40 117.674
R284 VDD.t84 VDD.t142 117.674
R285 VDD.t6 VDD.t126 117.674
R286 VDD.t138 VDD 106.543
R287 VDD.t52 VDD 106.543
R288 VDD.t136 VDD 106.543
R289 VDD.t62 VDD 106.543
R290 VDD.t94 VDD 106.543
R291 VDD.t24 VDD 106.543
R292 VDD.t96 VDD 106.543
R293 VDD.t114 VDD 106.543
R294 VDD.t22 VDD 106.543
R295 VDD.t30 VDD 100.454
R296 VDD.t46 VDD 100.454
R297 VDD.t112 VDD 100.454
R298 VDD.t28 VDD 100.454
R299 VDD.t110 VDD 100.454
R300 VDD.t38 VDD 100.454
R301 VDD.t124 VDD 100.454
R302 VDD.t40 VDD 100.454
R303 VDD.t126 VDD.n238 83.2331
R304 VDD VDD.t118 51.6621
R305 VDD VDD.t8 51.6621
R306 VDD VDD.t116 51.6621
R307 VDD VDD.t2 51.6621
R308 VDD VDD.t72 51.6621
R309 VDD VDD.t86 51.6621
R310 VDD VDD.t70 51.6621
R311 VDD VDD.t18 51.6621
R312 VDD VDD.t84 51.6621
R313 VDD.n156 VDD.n27 25.977
R314 VDD.n154 VDD.n153 25.977
R315 VDD.n151 VDD.n32 25.977
R316 VDD.n143 VDD.n39 25.977
R317 VDD.n135 VDD.n43 25.977
R318 VDD.n127 VDD.n47 25.977
R319 VDD.n119 VDD.n8 25.977
R320 VDD.n220 VDD.n5 25.977
R321 VDD.n229 VDD.n2 25.977
R322 VDD.n233 VDD.n3 25.977
R323 VDD.n224 VDD.n6 25.977
R324 VDD.n116 VDD.n112 25.977
R325 VDD.n124 VDD.n46 25.977
R326 VDD.n132 VDD.n42 25.977
R327 VDD.n140 VDD.n38 25.977
R328 VDD.n148 VDD.n37 25.977
R329 VDD.n161 VDD.n22 25.977
R330 VDD.n159 VDD.n1 25.977
R331 VDD.n57 VDD.n52 25.977
R332 VDD.n62 VDD.n51 25.977
R333 VDD.n64 VDD.n49 25.977
R334 VDD.n105 VDD.n69 25.977
R335 VDD.n103 VDD.n71 25.977
R336 VDD.n98 VDD.n97 25.977
R337 VDD.n95 VDD.n78 25.977
R338 VDD.n90 VDD.n89 25.977
R339 VDD.n87 VDD.n82 25.977
R340 VDD.n169 VDD.n166 25.977
R341 VDD.n174 VDD.n19 25.977
R342 VDD.n179 VDD.n18 25.977
R343 VDD.n184 VDD.n16 25.977
R344 VDD.n189 VDD.n15 25.977
R345 VDD.n194 VDD.n13 25.977
R346 VDD.n199 VDD.n12 25.977
R347 VDD.n213 VDD.n212 25.977
R348 VDD.n210 VDD.n205 25.977
R349 VDD.n27 VDD.n26 24.4711
R350 VDD.n155 VDD.n154 24.4711
R351 VDD.n152 VDD.n151 24.4711
R352 VDD.n144 VDD.n143 24.4711
R353 VDD.n136 VDD.n135 24.4711
R354 VDD.n128 VDD.n127 24.4711
R355 VDD.n120 VDD.n119 24.4711
R356 VDD.n220 VDD.n219 24.4711
R357 VDD.n229 VDD.n228 24.4711
R358 VDD.n234 VDD.n233 24.4711
R359 VDD.n225 VDD.n224 24.4711
R360 VDD.n116 VDD.n115 24.4711
R361 VDD.n124 VDD.n123 24.4711
R362 VDD.n132 VDD.n131 24.4711
R363 VDD.n140 VDD.n139 24.4711
R364 VDD.n148 VDD.n147 24.4711
R365 VDD.n36 VDD.n22 24.4711
R366 VDD.n160 VDD.n159 24.4711
R367 VDD.n53 VDD.n52 24.4711
R368 VDD.n58 VDD.n51 24.4711
R369 VDD.n64 VDD.n63 24.4711
R370 VDD.n69 VDD.n68 24.4711
R371 VDD.n104 VDD.n103 24.4711
R372 VDD.n99 VDD.n98 24.4711
R373 VDD.n96 VDD.n95 24.4711
R374 VDD.n91 VDD.n90 24.4711
R375 VDD.n88 VDD.n87 24.4711
R376 VDD.n169 VDD.n168 24.4711
R377 VDD.n174 VDD.n173 24.4711
R378 VDD.n179 VDD.n178 24.4711
R379 VDD.n184 VDD.n183 24.4711
R380 VDD.n189 VDD.n188 24.4711
R381 VDD.n194 VDD.n193 24.4711
R382 VDD.n199 VDD.n198 24.4711
R383 VDD.n213 VDD.n203 24.4711
R384 VDD.n211 VDD.n210 24.4711
R385 VDD.n238 VDD 17.221
R386 VDD.n156 VDD.n155 12.8005
R387 VDD.n153 VDD.n152 12.8005
R388 VDD.n144 VDD.n32 12.8005
R389 VDD.n136 VDD.n39 12.8005
R390 VDD.n128 VDD.n43 12.8005
R391 VDD.n120 VDD.n47 12.8005
R392 VDD.n219 VDD.n8 12.8005
R393 VDD.n228 VDD.n5 12.8005
R394 VDD.n237 VDD.n2 12.8005
R395 VDD.n225 VDD.n3 12.8005
R396 VDD.n115 VDD.n6 12.8005
R397 VDD.n123 VDD.n112 12.8005
R398 VDD.n131 VDD.n46 12.8005
R399 VDD.n139 VDD.n42 12.8005
R400 VDD.n147 VDD.n38 12.8005
R401 VDD.n37 VDD.n36 12.8005
R402 VDD.n161 VDD.n160 12.8005
R403 VDD.n239 VDD.n1 12.8005
R404 VDD.n58 VDD.n57 12.8005
R405 VDD.n63 VDD.n62 12.8005
R406 VDD.n68 VDD.n49 12.8005
R407 VDD.n105 VDD.n104 12.8005
R408 VDD.n99 VDD.n71 12.8005
R409 VDD.n97 VDD.n96 12.8005
R410 VDD.n91 VDD.n78 12.8005
R411 VDD.n89 VDD.n88 12.8005
R412 VDD.n83 VDD.n82 12.8005
R413 VDD.n173 VDD.n166 12.8005
R414 VDD.n178 VDD.n19 12.8005
R415 VDD.n183 VDD.n18 12.8005
R416 VDD.n188 VDD.n16 12.8005
R417 VDD.n193 VDD.n15 12.8005
R418 VDD.n198 VDD.n13 12.8005
R419 VDD.n203 VDD.n12 12.8005
R420 VDD.n212 VDD.n211 12.8005
R421 VDD.n206 VDD.n205 12.8005
R422 VDD.n207 VDD.n206 9.3005
R423 VDD.n168 VDD.n167 9.3005
R424 VDD.n170 VDD.n169 9.3005
R425 VDD.n171 VDD.n166 9.3005
R426 VDD.n173 VDD.n172 9.3005
R427 VDD.n175 VDD.n174 9.3005
R428 VDD.n176 VDD.n19 9.3005
R429 VDD.n178 VDD.n177 9.3005
R430 VDD.n180 VDD.n179 9.3005
R431 VDD.n181 VDD.n18 9.3005
R432 VDD.n183 VDD.n182 9.3005
R433 VDD.n185 VDD.n184 9.3005
R434 VDD.n186 VDD.n16 9.3005
R435 VDD.n188 VDD.n187 9.3005
R436 VDD.n190 VDD.n189 9.3005
R437 VDD.n191 VDD.n15 9.3005
R438 VDD.n193 VDD.n192 9.3005
R439 VDD.n195 VDD.n194 9.3005
R440 VDD.n196 VDD.n13 9.3005
R441 VDD.n198 VDD.n197 9.3005
R442 VDD.n200 VDD.n199 9.3005
R443 VDD.n201 VDD.n12 9.3005
R444 VDD.n203 VDD.n202 9.3005
R445 VDD.n214 VDD.n213 9.3005
R446 VDD.n212 VDD.n11 9.3005
R447 VDD.n211 VDD.n204 9.3005
R448 VDD.n210 VDD.n209 9.3005
R449 VDD.n208 VDD.n205 9.3005
R450 VDD.n84 VDD.n83 9.3005
R451 VDD.n85 VDD.n82 9.3005
R452 VDD.n87 VDD.n86 9.3005
R453 VDD.n88 VDD.n81 9.3005
R454 VDD.n89 VDD.n80 9.3005
R455 VDD.n90 VDD.n79 9.3005
R456 VDD.n92 VDD.n91 9.3005
R457 VDD.n93 VDD.n78 9.3005
R458 VDD.n95 VDD.n94 9.3005
R459 VDD.n96 VDD.n77 9.3005
R460 VDD.n97 VDD.n73 9.3005
R461 VDD.n98 VDD.n72 9.3005
R462 VDD.n100 VDD.n99 9.3005
R463 VDD.n101 VDD.n71 9.3005
R464 VDD.n103 VDD.n102 9.3005
R465 VDD.n104 VDD.n70 9.3005
R466 VDD.n106 VDD.n105 9.3005
R467 VDD.n69 VDD.n48 9.3005
R468 VDD.n68 VDD.n67 9.3005
R469 VDD.n66 VDD.n49 9.3005
R470 VDD.n65 VDD.n64 9.3005
R471 VDD.n63 VDD.n50 9.3005
R472 VDD.n62 VDD.n61 9.3005
R473 VDD.n60 VDD.n51 9.3005
R474 VDD.n59 VDD.n58 9.3005
R475 VDD.n57 VDD.n56 9.3005
R476 VDD.n55 VDD.n52 9.3005
R477 VDD.n54 VDD.n53 9.3005
R478 VDD.n240 VDD.n239 9.3005
R479 VDD.n24 VDD.n1 9.3005
R480 VDD.n159 VDD.n158 9.3005
R481 VDD.n160 VDD.n23 9.3005
R482 VDD.n162 VDD.n161 9.3005
R483 VDD.n29 VDD.n22 9.3005
R484 VDD.n36 VDD.n35 9.3005
R485 VDD.n37 VDD.n33 9.3005
R486 VDD.n149 VDD.n148 9.3005
R487 VDD.n147 VDD.n146 9.3005
R488 VDD.n40 VDD.n38 9.3005
R489 VDD.n141 VDD.n140 9.3005
R490 VDD.n139 VDD.n138 9.3005
R491 VDD.n44 VDD.n42 9.3005
R492 VDD.n133 VDD.n132 9.3005
R493 VDD.n131 VDD.n130 9.3005
R494 VDD.n110 VDD.n46 9.3005
R495 VDD.n125 VDD.n124 9.3005
R496 VDD.n123 VDD.n122 9.3005
R497 VDD.n113 VDD.n112 9.3005
R498 VDD.n117 VDD.n116 9.3005
R499 VDD.n115 VDD.n9 9.3005
R500 VDD.n7 VDD.n6 9.3005
R501 VDD.n224 VDD.n223 9.3005
R502 VDD.n226 VDD.n225 9.3005
R503 VDD.n4 VDD.n3 9.3005
R504 VDD.n233 VDD.n232 9.3005
R505 VDD.n235 VDD.n234 9.3005
R506 VDD.n237 VDD.n236 9.3005
R507 VDD.n26 VDD.n0 9.3005
R508 VDD.n27 VDD.n25 9.3005
R509 VDD.n157 VDD.n156 9.3005
R510 VDD.n155 VDD.n28 9.3005
R511 VDD.n154 VDD.n21 9.3005
R512 VDD.n153 VDD.n30 9.3005
R513 VDD.n152 VDD.n31 9.3005
R514 VDD.n151 VDD.n150 9.3005
R515 VDD.n34 VDD.n32 9.3005
R516 VDD.n145 VDD.n144 9.3005
R517 VDD.n143 VDD.n142 9.3005
R518 VDD.n41 VDD.n39 9.3005
R519 VDD.n137 VDD.n136 9.3005
R520 VDD.n135 VDD.n134 9.3005
R521 VDD.n45 VDD.n43 9.3005
R522 VDD.n129 VDD.n128 9.3005
R523 VDD.n127 VDD.n126 9.3005
R524 VDD.n111 VDD.n47 9.3005
R525 VDD.n121 VDD.n120 9.3005
R526 VDD.n119 VDD.n118 9.3005
R527 VDD.n114 VDD.n8 9.3005
R528 VDD.n219 VDD.n218 9.3005
R529 VDD.n221 VDD.n220 9.3005
R530 VDD.n222 VDD.n5 9.3005
R531 VDD.n228 VDD.n227 9.3005
R532 VDD.n230 VDD.n229 9.3005
R533 VDD.n231 VDD.n2 9.3005
R534 VDD.n108 VDD.n107 8.67487
R535 VDD.n76 VDD.n75 8.67363
R536 VDD.n216 VDD.n10 8.67363
R537 VDD.n164 VDD.n20 8.67239
R538 VDD.n165 VDD.n164 8.67116
R539 VDD.n216 VDD.n215 8.67116
R540 VDD.n75 VDD.n17 8.66992
R541 VDD.n108 VDD.n14 8.66868
R542 VDD.n217 VDD.n216 7.9105
R543 VDD.n75 VDD.n74 7.9105
R544 VDD.n164 VDD.n163 7.9105
R545 VDD.n109 VDD.n108 7.9105
R546 VDD.t44 VDD.t120 2.87059
R547 VDD.t98 VDD.t122 2.87059
R548 VDD.t26 VDD.t4 2.87059
R549 VDD.t34 VDD.t76 2.87059
R550 VDD.t32 VDD.t80 2.87059
R551 VDD.t36 VDD.t78 2.87059
R552 VDD.t42 VDD.t82 2.87059
R553 VDD.t140 VDD.t92 2.87059
R554 VDD.t142 VDD.t6 2.87059
R555 VDD.n171 VDD.n170 0.120292
R556 VDD.n176 VDD.n175 0.120292
R557 VDD.n181 VDD.n180 0.120292
R558 VDD.n186 VDD.n185 0.120292
R559 VDD.n191 VDD.n190 0.120292
R560 VDD.n196 VDD.n195 0.120292
R561 VDD.n201 VDD.n200 0.120292
R562 VDD.n214 VDD.n11 0.120292
R563 VDD.n209 VDD.n208 0.120292
R564 VDD.n86 VDD.n85 0.120292
R565 VDD.n86 VDD.n81 0.120292
R566 VDD.n80 VDD.n79 0.120292
R567 VDD.n92 VDD.n79 0.120292
R568 VDD.n94 VDD.n93 0.120292
R569 VDD.n94 VDD.n77 0.120292
R570 VDD.n73 VDD.n72 0.120292
R571 VDD.n100 VDD.n72 0.120292
R572 VDD.n102 VDD.n101 0.120292
R573 VDD.n102 VDD.n70 0.120292
R574 VDD.n106 VDD.n48 0.120292
R575 VDD.n67 VDD.n48 0.120292
R576 VDD.n66 VDD.n65 0.120292
R577 VDD.n65 VDD.n50 0.120292
R578 VDD.n61 VDD.n60 0.120292
R579 VDD.n60 VDD.n59 0.120292
R580 VDD.n56 VDD.n55 0.120292
R581 VDD.n55 VDD.n54 0.120292
R582 VDD.n170 VDD 0.0994583
R583 VDD.n180 VDD 0.0994583
R584 VDD.n190 VDD 0.0994583
R585 VDD.n200 VDD 0.0994583
R586 VDD.n209 VDD 0.0994583
R587 VDD.n185 VDD.n17 0.0708125
R588 VDD.n175 VDD.n165 0.0656042
R589 VDD.n195 VDD.n14 0.0656042
R590 VDD.n215 VDD.n214 0.0656042
R591 VDD.n167 VDD 0.0603958
R592 VDD VDD.n171 0.0603958
R593 VDD.n172 VDD 0.0603958
R594 VDD VDD.n176 0.0603958
R595 VDD.n177 VDD 0.0603958
R596 VDD VDD.n181 0.0603958
R597 VDD.n182 VDD 0.0603958
R598 VDD VDD.n186 0.0603958
R599 VDD.n187 VDD 0.0603958
R600 VDD VDD.n191 0.0603958
R601 VDD.n192 VDD 0.0603958
R602 VDD VDD.n196 0.0603958
R603 VDD.n197 VDD 0.0603958
R604 VDD VDD.n201 0.0603958
R605 VDD.n202 VDD 0.0603958
R606 VDD VDD.n11 0.0603958
R607 VDD.n204 VDD 0.0603958
R608 VDD.n208 VDD 0.0603958
R609 VDD VDD.n207 0.0603958
R610 VDD.n84 VDD 0.0603958
R611 VDD.n85 VDD 0.0603958
R612 VDD.n93 VDD 0.0603958
R613 VDD VDD.n73 0.0603958
R614 VDD.n101 VDD 0.0603958
R615 VDD VDD.n66 0.0603958
R616 VDD.n56 VDD 0.0603958
R617 VDD.n80 VDD.n20 0.0577917
R618 VDD.n107 VDD.n106 0.0577917
R619 VDD.n61 VDD.n10 0.0577917
R620 VDD.n158 VDD.n25 0.0564896
R621 VDD.n29 VDD.n21 0.0564896
R622 VDD.n150 VDD.n149 0.0564896
R623 VDD.n142 VDD.n141 0.0564896
R624 VDD.n134 VDD.n133 0.0564896
R625 VDD.n126 VDD.n125 0.0564896
R626 VDD.n118 VDD.n117 0.0564896
R627 VDD.n223 VDD.n221 0.0564896
R628 VDD.n232 VDD.n230 0.0564896
R629 VDD.n207 VDD 0.0382604
R630 VDD VDD.n165 0.0343542
R631 VDD VDD.n14 0.0343542
R632 VDD.n215 VDD 0.0343542
R633 VDD VDD.n76 0.0343542
R634 VDD VDD.n84 0.03175
R635 VDD.n24 VDD 0.0304479
R636 VDD.n157 VDD 0.0304479
R637 VDD VDD.n30 0.0304479
R638 VDD.n33 VDD 0.0304479
R639 VDD VDD.n34 0.0304479
R640 VDD VDD.n40 0.0304479
R641 VDD VDD.n41 0.0304479
R642 VDD.n44 VDD 0.0304479
R643 VDD VDD.n45 0.0304479
R644 VDD VDD.n111 0.0304479
R645 VDD.n113 VDD 0.0304479
R646 VDD.n114 VDD 0.0304479
R647 VDD.n222 VDD 0.0304479
R648 VDD VDD.n4 0.0304479
R649 VDD.n231 VDD 0.0304479
R650 VDD VDD.n17 0.0291458
R651 VDD.n163 VDD.n162 0.0291458
R652 VDD.n110 VDD.n109 0.0291458
R653 VDD.n217 VDD.n7 0.0291458
R654 VDD VDD.n240 0.0265417
R655 VDD VDD.n23 0.0265417
R656 VDD.n35 VDD 0.0265417
R657 VDD.n146 VDD 0.0265417
R658 VDD.n138 VDD 0.0265417
R659 VDD.n130 VDD 0.0265417
R660 VDD.n122 VDD 0.0265417
R661 VDD VDD.n9 0.0265417
R662 VDD.n226 VDD 0.0265417
R663 VDD.n235 VDD 0.0265417
R664 VDD.n81 VDD 0.0239375
R665 VDD VDD.n92 0.0239375
R666 VDD.n77 VDD 0.0239375
R667 VDD VDD.n100 0.0239375
R668 VDD.n70 VDD 0.0239375
R669 VDD.n67 VDD 0.0239375
R670 VDD.n50 VDD 0.0239375
R671 VDD.n59 VDD 0.0239375
R672 VDD.n54 VDD 0.0239375
R673 VDD.n167 VDD 0.0213333
R674 VDD.n172 VDD 0.0213333
R675 VDD.n177 VDD 0.0213333
R676 VDD.n182 VDD 0.0213333
R677 VDD.n187 VDD 0.0213333
R678 VDD.n192 VDD 0.0213333
R679 VDD.n197 VDD 0.0213333
R680 VDD.n202 VDD 0.0213333
R681 VDD VDD.n204 0.0213333
R682 VDD.n74 VDD 0.0148229
R683 VDD VDD.n0 0.0109167
R684 VDD.n28 VDD 0.0083125
R685 VDD VDD.n31 0.0083125
R686 VDD.n145 VDD 0.0083125
R687 VDD.n137 VDD 0.0083125
R688 VDD.n129 VDD 0.0083125
R689 VDD.n121 VDD 0.0083125
R690 VDD.n218 VDD 0.0083125
R691 VDD.n227 VDD 0.0083125
R692 VDD.n236 VDD 0.0083125
R693 VDD.n240 VDD.n0 0.00440625
R694 VDD.n25 VDD.n24 0.00440625
R695 VDD.n158 VDD.n157 0.00440625
R696 VDD.n28 VDD.n23 0.00440625
R697 VDD.n162 VDD.n21 0.00440625
R698 VDD.n30 VDD.n29 0.00440625
R699 VDD.n35 VDD.n31 0.00440625
R700 VDD.n150 VDD.n33 0.00440625
R701 VDD.n149 VDD.n34 0.00440625
R702 VDD.n146 VDD.n145 0.00440625
R703 VDD.n142 VDD.n40 0.00440625
R704 VDD.n141 VDD.n41 0.00440625
R705 VDD.n138 VDD.n137 0.00440625
R706 VDD.n134 VDD.n44 0.00440625
R707 VDD.n133 VDD.n45 0.00440625
R708 VDD.n130 VDD.n129 0.00440625
R709 VDD.n126 VDD.n110 0.00440625
R710 VDD.n125 VDD.n111 0.00440625
R711 VDD.n122 VDD.n121 0.00440625
R712 VDD.n118 VDD.n113 0.00440625
R713 VDD.n117 VDD.n114 0.00440625
R714 VDD.n218 VDD.n9 0.00440625
R715 VDD.n221 VDD.n7 0.00440625
R716 VDD.n223 VDD.n222 0.00440625
R717 VDD.n227 VDD.n226 0.00440625
R718 VDD.n230 VDD.n4 0.00440625
R719 VDD.n232 VDD.n231 0.00440625
R720 VDD.n236 VDD.n235 0.00440625
R721 VDD VDD.n20 0.00310417
R722 VDD.n76 VDD 0.00310417
R723 VDD.n107 VDD 0.00310417
R724 VDD VDD.n10 0.00310417
R725 VDD.n163 VDD 0.00180208
R726 VDD.n74 VDD 0.00180208
R727 VDD.n109 VDD 0.00180208
R728 VDD VDD.n217 0.00180208
R729 GND GND.n2 1.46388e+06
R730 GND.n233 GND.n2 110280
R731 GND.n151 GND.n150 1198.25
R732 GND.n233 GND.n232 1198.25
R733 GND.n235 GND.n234 1198.25
R734 GND.n153 GND.n152 1198.25
R735 GND.n151 GND.n2 662.136
R736 GND.t34 GND.t104 583.819
R737 GND.t24 GND.t97 583.819
R738 GND.t72 GND.t39 583.819
R739 GND.t35 GND.t96 583.819
R740 GND.t23 GND.t102 583.819
R741 GND.t82 GND.t38 583.819
R742 GND.t27 GND.t45 583.819
R743 GND.t21 GND.t55 583.819
R744 GND.t26 GND.t68 583.819
R745 GND.t80 GND.t42 583.819
R746 GND.t28 GND.t19 583.819
R747 GND.t29 GND.t41 583.819
R748 GND.t33 GND.t70 583.819
R749 GND.t92 GND.t18 583.819
R750 GND.t107 GND.t84 583.819
R751 GND.t31 GND.t79 583.819
R752 GND.t106 GND.t16 583.819
R753 GND.t94 GND.t37 583.819
R754 GND.t50 GND.t88 583.819
R755 GND.t12 GND.t91 583.819
R756 GND.t64 GND.t5 583.819
R757 GND.t7 GND.t90 583.819
R758 GND.t11 GND.t86 583.819
R759 GND.t100 GND.t4 583.819
R760 GND.t44 GND.t1 583.819
R761 GND.t9 GND.t56 583.819
R762 GND.t43 GND.t51 583.819
R763 GND.t98 GND.t58 583.819
R764 GND.t0 GND.t62 583.819
R765 GND.t65 GND.t57 583.819
R766 GND.t49 GND.t53 583.819
R767 GND.t75 GND.t61 583.819
R768 GND.t74 GND.t14 583.819
R769 GND.t47 GND.t67 583.819
R770 GND.t73 GND.t59 583.819
R771 GND.t77 GND.t3 583.819
R772 GND GND.t24 498.382
R773 GND GND.t35 498.382
R774 GND GND.t82 498.382
R775 GND GND.t21 498.382
R776 GND GND.t80 498.382
R777 GND GND.t29 498.382
R778 GND GND.t92 498.382
R779 GND GND.t31 498.382
R780 GND GND.t12 498.382
R781 GND GND.t7 498.382
R782 GND GND.t100 498.382
R783 GND GND.t9 498.382
R784 GND GND.t98 498.382
R785 GND GND.t65 498.382
R786 GND GND.t75 498.382
R787 GND GND.t47 498.382
R788 GND.n234 GND.t94 412.945
R789 GND.n152 GND.t77 412.945
R790 GND.t104 GND 256.312
R791 GND.t39 GND 256.312
R792 GND.t102 GND 256.312
R793 GND.t45 GND 256.312
R794 GND.t68 GND 256.312
R795 GND.t19 GND 256.312
R796 GND.t70 GND 256.312
R797 GND.t84 GND 256.312
R798 GND.t16 GND 256.312
R799 GND.t88 GND 256.312
R800 GND.t5 GND 256.312
R801 GND.t86 GND 256.312
R802 GND.t1 GND 256.312
R803 GND.t51 GND 256.312
R804 GND.t62 GND 256.312
R805 GND.t53 GND 256.312
R806 GND.t14 GND 256.312
R807 GND.t59 GND 256.312
R808 GND GND.n233 156.635
R809 GND GND.n151 156.635
R810 GND.n224 GND.t25 150.922
R811 GND.n216 GND.t36 150.922
R812 GND.n208 GND.t83 150.922
R813 GND.n200 GND.t22 150.922
R814 GND.n192 GND.t81 150.922
R815 GND.n184 GND.t30 150.922
R816 GND.n176 GND.t93 150.922
R817 GND.n168 GND.t32 150.922
R818 GND.n40 GND.t95 150.922
R819 GND.n38 GND.t17 150.922
R820 GND.n34 GND.t85 150.922
R821 GND.n29 GND.t71 150.922
R822 GND.n25 GND.t20 150.922
R823 GND.n20 GND.t69 150.922
R824 GND.n16 GND.t46 150.922
R825 GND.n12 GND.t103 150.922
R826 GND.n11 GND.t40 150.922
R827 GND.n229 GND.t105 150.922
R828 GND.n142 GND.t13 150.922
R829 GND.n134 GND.t8 150.922
R830 GND.n126 GND.t101 150.922
R831 GND.n118 GND.t10 150.922
R832 GND.n110 GND.t99 150.922
R833 GND.n102 GND.t66 150.922
R834 GND.n94 GND.t76 150.922
R835 GND.n43 GND.t48 150.922
R836 GND.n44 GND.t78 150.922
R837 GND.n85 GND.t60 150.922
R838 GND.n81 GND.t15 150.922
R839 GND.n76 GND.t54 150.922
R840 GND.n72 GND.t63 150.922
R841 GND.n67 GND.t52 150.922
R842 GND.n63 GND.t2 150.922
R843 GND.n57 GND.t87 150.922
R844 GND.n56 GND.t6 150.922
R845 GND.n147 GND.t89 150.922
R846 GND.n234 GND 85.4374
R847 GND.n152 GND 85.4374
R848 GND.n225 GND.n3 34.6358
R849 GND.n223 GND.n8 34.6358
R850 GND.n215 GND.n14 34.6358
R851 GND.n207 GND.n18 34.6358
R852 GND.n199 GND.n22 34.6358
R853 GND.n191 GND.n27 34.6358
R854 GND.n183 GND.n31 34.6358
R855 GND.n175 GND.n36 34.6358
R856 GND.n167 GND.n41 34.6358
R857 GND.n164 GND.n1 34.6358
R858 GND.n172 GND.n171 34.6358
R859 GND.n180 GND.n179 34.6358
R860 GND.n188 GND.n187 34.6358
R861 GND.n196 GND.n195 34.6358
R862 GND.n204 GND.n203 34.6358
R863 GND.n212 GND.n211 34.6358
R864 GND.n220 GND.n219 34.6358
R865 GND.n228 GND.n4 34.6358
R866 GND.n143 GND.n48 34.6358
R867 GND.n141 GND.n53 34.6358
R868 GND.n133 GND.n59 34.6358
R869 GND.n125 GND.n65 34.6358
R870 GND.n117 GND.n69 34.6358
R871 GND.n109 GND.n74 34.6358
R872 GND.n101 GND.n78 34.6358
R873 GND.n93 GND.n83 34.6358
R874 GND.n158 GND.n157 34.6358
R875 GND.n154 GND.n45 34.6358
R876 GND.n90 GND.n89 34.6358
R877 GND.n98 GND.n97 34.6358
R878 GND.n106 GND.n105 34.6358
R879 GND.n114 GND.n113 34.6358
R880 GND.n122 GND.n121 34.6358
R881 GND.n130 GND.n129 34.6358
R882 GND.n138 GND.n137 34.6358
R883 GND.n146 GND.n49 34.6358
R884 GND.n232 GND.n3 23.7181
R885 GND.n224 GND.n223 23.7181
R886 GND.n216 GND.n215 23.7181
R887 GND.n208 GND.n207 23.7181
R888 GND.n200 GND.n199 23.7181
R889 GND.n192 GND.n191 23.7181
R890 GND.n184 GND.n183 23.7181
R891 GND.n176 GND.n175 23.7181
R892 GND.n168 GND.n167 23.7181
R893 GND.n235 GND.n1 23.7181
R894 GND.n171 GND.n38 23.7181
R895 GND.n179 GND.n34 23.7181
R896 GND.n187 GND.n29 23.7181
R897 GND.n195 GND.n25 23.7181
R898 GND.n203 GND.n20 23.7181
R899 GND.n211 GND.n16 23.7181
R900 GND.n219 GND.n12 23.7181
R901 GND.n11 GND.n4 23.7181
R902 GND.n150 GND.n48 23.7181
R903 GND.n142 GND.n141 23.7181
R904 GND.n134 GND.n133 23.7181
R905 GND.n126 GND.n125 23.7181
R906 GND.n118 GND.n117 23.7181
R907 GND.n110 GND.n109 23.7181
R908 GND.n102 GND.n101 23.7181
R909 GND.n94 GND.n93 23.7181
R910 GND.n158 GND.n43 23.7181
R911 GND.n154 GND.n153 23.7181
R912 GND.n89 GND.n85 23.7181
R913 GND.n97 GND.n81 23.7181
R914 GND.n105 GND.n76 23.7181
R915 GND.n113 GND.n72 23.7181
R916 GND.n121 GND.n67 23.7181
R917 GND.n129 GND.n63 23.7181
R918 GND.n137 GND.n57 23.7181
R919 GND.n56 GND.n49 23.7181
R920 GND.n225 GND.n224 22.2123
R921 GND.n216 GND.n8 22.2123
R922 GND.n208 GND.n14 22.2123
R923 GND.n200 GND.n18 22.2123
R924 GND.n192 GND.n22 22.2123
R925 GND.n184 GND.n27 22.2123
R926 GND.n176 GND.n31 22.2123
R927 GND.n168 GND.n36 22.2123
R928 GND.n41 GND.n40 22.2123
R929 GND.n164 GND.n38 22.2123
R930 GND.n172 GND.n34 22.2123
R931 GND.n180 GND.n29 22.2123
R932 GND.n188 GND.n25 22.2123
R933 GND.n196 GND.n20 22.2123
R934 GND.n204 GND.n16 22.2123
R935 GND.n212 GND.n12 22.2123
R936 GND.n220 GND.n11 22.2123
R937 GND.n229 GND.n228 22.2123
R938 GND.n143 GND.n142 22.2123
R939 GND.n134 GND.n53 22.2123
R940 GND.n126 GND.n59 22.2123
R941 GND.n118 GND.n65 22.2123
R942 GND.n110 GND.n69 22.2123
R943 GND.n102 GND.n74 22.2123
R944 GND.n94 GND.n78 22.2123
R945 GND.n83 GND.n43 22.2123
R946 GND.n157 GND.n44 22.2123
R947 GND.n85 GND.n45 22.2123
R948 GND.n90 GND.n81 22.2123
R949 GND.n98 GND.n76 22.2123
R950 GND.n106 GND.n72 22.2123
R951 GND.n114 GND.n67 22.2123
R952 GND.n122 GND.n63 22.2123
R953 GND.n130 GND.n57 22.2123
R954 GND.n138 GND.n56 22.2123
R955 GND.n147 GND.n146 22.2123
R956 GND.n61 GND.n60 16.6211
R957 GND.n70 GND.n23 16.6191
R958 GND.n161 GND.n160 16.6096
R959 GND.n79 GND.n32 16.6096
R960 GND.t97 GND.t34 14.24
R961 GND.t96 GND.t72 14.24
R962 GND.t38 GND.t23 14.24
R963 GND.t55 GND.t27 14.24
R964 GND.t42 GND.t26 14.24
R965 GND.t41 GND.t28 14.24
R966 GND.t18 GND.t33 14.24
R967 GND.t79 GND.t107 14.24
R968 GND.t37 GND.t106 14.24
R969 GND.t91 GND.t50 14.24
R970 GND.t90 GND.t64 14.24
R971 GND.t4 GND.t11 14.24
R972 GND.t56 GND.t44 14.24
R973 GND.t58 GND.t43 14.24
R974 GND.t57 GND.t0 14.24
R975 GND.t61 GND.t49 14.24
R976 GND.t67 GND.t74 14.24
R977 GND.t3 GND.t73 14.24
R978 GND.n148 GND.n147 9.3005
R979 GND.n146 GND.n145 9.3005
R980 GND.n51 GND.n49 9.3005
R981 GND.n56 GND.n55 9.3005
R982 GND.n139 GND.n138 9.3005
R983 GND.n137 GND.n136 9.3005
R984 GND.n58 GND.n57 9.3005
R985 GND.n131 GND.n130 9.3005
R986 GND.n129 GND.n128 9.3005
R987 GND.n64 GND.n63 9.3005
R988 GND.n123 GND.n122 9.3005
R989 GND.n121 GND.n120 9.3005
R990 GND.n68 GND.n67 9.3005
R991 GND.n115 GND.n114 9.3005
R992 GND.n113 GND.n112 9.3005
R993 GND.n73 GND.n72 9.3005
R994 GND.n107 GND.n106 9.3005
R995 GND.n105 GND.n104 9.3005
R996 GND.n77 GND.n76 9.3005
R997 GND.n99 GND.n98 9.3005
R998 GND.n97 GND.n96 9.3005
R999 GND.n82 GND.n81 9.3005
R1000 GND.n91 GND.n90 9.3005
R1001 GND.n89 GND.n88 9.3005
R1002 GND.n86 GND.n85 9.3005
R1003 GND.n45 GND.n42 9.3005
R1004 GND.n155 GND.n154 9.3005
R1005 GND.n153 GND.n47 9.3005
R1006 GND.n46 GND.n44 9.3005
R1007 GND.n150 GND.n149 9.3005
R1008 GND.n50 GND.n48 9.3005
R1009 GND.n144 GND.n143 9.3005
R1010 GND.n142 GND.n52 9.3005
R1011 GND.n141 GND.n140 9.3005
R1012 GND.n54 GND.n53 9.3005
R1013 GND.n135 GND.n134 9.3005
R1014 GND.n133 GND.n132 9.3005
R1015 GND.n62 GND.n59 9.3005
R1016 GND.n127 GND.n126 9.3005
R1017 GND.n125 GND.n124 9.3005
R1018 GND.n66 GND.n65 9.3005
R1019 GND.n119 GND.n118 9.3005
R1020 GND.n117 GND.n116 9.3005
R1021 GND.n71 GND.n69 9.3005
R1022 GND.n111 GND.n110 9.3005
R1023 GND.n109 GND.n108 9.3005
R1024 GND.n75 GND.n74 9.3005
R1025 GND.n103 GND.n102 9.3005
R1026 GND.n101 GND.n100 9.3005
R1027 GND.n80 GND.n78 9.3005
R1028 GND.n95 GND.n94 9.3005
R1029 GND.n93 GND.n92 9.3005
R1030 GND.n84 GND.n83 9.3005
R1031 GND.n87 GND.n43 9.3005
R1032 GND.n159 GND.n158 9.3005
R1033 GND.n157 GND.n156 9.3005
R1034 GND.n230 GND.n229 9.3005
R1035 GND.n228 GND.n227 9.3005
R1036 GND.n6 GND.n4 9.3005
R1037 GND.n11 GND.n10 9.3005
R1038 GND.n221 GND.n220 9.3005
R1039 GND.n219 GND.n218 9.3005
R1040 GND.n13 GND.n12 9.3005
R1041 GND.n213 GND.n212 9.3005
R1042 GND.n211 GND.n210 9.3005
R1043 GND.n17 GND.n16 9.3005
R1044 GND.n205 GND.n204 9.3005
R1045 GND.n203 GND.n202 9.3005
R1046 GND.n21 GND.n20 9.3005
R1047 GND.n197 GND.n196 9.3005
R1048 GND.n195 GND.n194 9.3005
R1049 GND.n26 GND.n25 9.3005
R1050 GND.n189 GND.n188 9.3005
R1051 GND.n187 GND.n186 9.3005
R1052 GND.n30 GND.n29 9.3005
R1053 GND.n181 GND.n180 9.3005
R1054 GND.n179 GND.n178 9.3005
R1055 GND.n35 GND.n34 9.3005
R1056 GND.n173 GND.n172 9.3005
R1057 GND.n171 GND.n170 9.3005
R1058 GND.n39 GND.n38 9.3005
R1059 GND.n165 GND.n164 9.3005
R1060 GND.n162 GND.n1 9.3005
R1061 GND.n236 GND.n235 9.3005
R1062 GND.n40 GND.n0 9.3005
R1063 GND.n232 GND.n231 9.3005
R1064 GND.n5 GND.n3 9.3005
R1065 GND.n226 GND.n225 9.3005
R1066 GND.n224 GND.n7 9.3005
R1067 GND.n223 GND.n222 9.3005
R1068 GND.n9 GND.n8 9.3005
R1069 GND.n217 GND.n216 9.3005
R1070 GND.n215 GND.n214 9.3005
R1071 GND.n15 GND.n14 9.3005
R1072 GND.n209 GND.n208 9.3005
R1073 GND.n207 GND.n206 9.3005
R1074 GND.n19 GND.n18 9.3005
R1075 GND.n201 GND.n200 9.3005
R1076 GND.n199 GND.n198 9.3005
R1077 GND.n24 GND.n22 9.3005
R1078 GND.n193 GND.n192 9.3005
R1079 GND.n191 GND.n190 9.3005
R1080 GND.n28 GND.n27 9.3005
R1081 GND.n185 GND.n184 9.3005
R1082 GND.n183 GND.n182 9.3005
R1083 GND.n33 GND.n31 9.3005
R1084 GND.n177 GND.n176 9.3005
R1085 GND.n175 GND.n174 9.3005
R1086 GND.n37 GND.n36 9.3005
R1087 GND.n169 GND.n168 9.3005
R1088 GND.n167 GND.n166 9.3005
R1089 GND.n163 GND.n41 9.3005
R1090 GND.n145 GND.n144 0.0564896
R1091 GND.n139 GND.n54 0.0564896
R1092 GND.n131 GND.n62 0.0564896
R1093 GND.n123 GND.n66 0.0564896
R1094 GND.n115 GND.n71 0.0564896
R1095 GND.n107 GND.n75 0.0564896
R1096 GND.n99 GND.n80 0.0564896
R1097 GND.n91 GND.n84 0.0564896
R1098 GND.n156 GND.n42 0.0564896
R1099 GND.n227 GND.n226 0.0564896
R1100 GND.n221 GND.n9 0.0564896
R1101 GND.n213 GND.n15 0.0564896
R1102 GND.n205 GND.n19 0.0564896
R1103 GND.n197 GND.n24 0.0564896
R1104 GND.n189 GND.n28 0.0564896
R1105 GND.n181 GND.n33 0.0564896
R1106 GND.n173 GND.n37 0.0564896
R1107 GND.n165 GND.n163 0.0564896
R1108 GND.n50 GND 0.0304479
R1109 GND GND.n51 0.0304479
R1110 GND.n140 GND 0.0304479
R1111 GND.n136 GND 0.0304479
R1112 GND.n128 GND 0.0304479
R1113 GND.n124 GND 0.0304479
R1114 GND.n120 GND 0.0304479
R1115 GND.n112 GND 0.0304479
R1116 GND.n108 GND 0.0304479
R1117 GND.n104 GND 0.0304479
R1118 GND.n96 GND 0.0304479
R1119 GND.n92 GND 0.0304479
R1120 GND.n88 GND 0.0304479
R1121 GND.n155 GND 0.0304479
R1122 GND.n231 GND 0.0304479
R1123 GND.n5 GND 0.0304479
R1124 GND GND.n6 0.0304479
R1125 GND.n222 GND 0.0304479
R1126 GND.n218 GND 0.0304479
R1127 GND.n214 GND 0.0304479
R1128 GND.n210 GND 0.0304479
R1129 GND.n206 GND 0.0304479
R1130 GND.n202 GND 0.0304479
R1131 GND.n194 GND 0.0304479
R1132 GND.n190 GND 0.0304479
R1133 GND.n186 GND 0.0304479
R1134 GND.n178 GND 0.0304479
R1135 GND.n174 GND 0.0304479
R1136 GND.n170 GND 0.0304479
R1137 GND.n162 GND 0.0304479
R1138 GND.n132 GND.n61 0.0291458
R1139 GND.n116 GND.n70 0.0291458
R1140 GND.n160 GND.n159 0.0291458
R1141 GND.n198 GND.n23 0.0291458
R1142 GND.n166 GND.n161 0.0291458
R1143 GND.n149 GND 0.0265417
R1144 GND.n52 GND 0.0265417
R1145 GND GND.n135 0.0265417
R1146 GND GND.n127 0.0265417
R1147 GND GND.n119 0.0265417
R1148 GND GND.n111 0.0265417
R1149 GND GND.n103 0.0265417
R1150 GND.n100 GND.n79 0.0265417
R1151 GND GND.n95 0.0265417
R1152 GND GND.n87 0.0265417
R1153 GND.n46 GND 0.0265417
R1154 GND.n7 GND 0.0265417
R1155 GND GND.n217 0.0265417
R1156 GND GND.n209 0.0265417
R1157 GND GND.n201 0.0265417
R1158 GND GND.n193 0.0265417
R1159 GND GND.n185 0.0265417
R1160 GND.n182 GND.n32 0.0265417
R1161 GND GND.n177 0.0265417
R1162 GND GND.n169 0.0265417
R1163 GND GND.n0 0.0265417
R1164 GND.n60 GND 0.0148229
R1165 GND.n148 GND 0.0109167
R1166 GND.n230 GND 0.0109167
R1167 GND.n55 GND 0.0083125
R1168 GND GND.n58 0.0083125
R1169 GND GND.n64 0.0083125
R1170 GND GND.n68 0.0083125
R1171 GND GND.n73 0.0083125
R1172 GND GND.n77 0.0083125
R1173 GND GND.n82 0.0083125
R1174 GND.n86 GND 0.0083125
R1175 GND.n47 GND 0.0083125
R1176 GND.n10 GND 0.0083125
R1177 GND GND.n13 0.0083125
R1178 GND GND.n17 0.0083125
R1179 GND GND.n21 0.0083125
R1180 GND GND.n26 0.0083125
R1181 GND GND.n30 0.0083125
R1182 GND GND.n35 0.0083125
R1183 GND GND.n39 0.0083125
R1184 GND GND.n236 0.0083125
R1185 GND.n149 GND.n148 0.00440625
R1186 GND.n145 GND.n50 0.00440625
R1187 GND.n144 GND.n51 0.00440625
R1188 GND.n55 GND.n52 0.00440625
R1189 GND.n140 GND.n139 0.00440625
R1190 GND.n136 GND.n54 0.00440625
R1191 GND.n135 GND.n58 0.00440625
R1192 GND.n132 GND.n131 0.00440625
R1193 GND.n128 GND.n62 0.00440625
R1194 GND.n127 GND.n64 0.00440625
R1195 GND.n124 GND.n123 0.00440625
R1196 GND.n120 GND.n66 0.00440625
R1197 GND.n119 GND.n68 0.00440625
R1198 GND.n116 GND.n115 0.00440625
R1199 GND.n112 GND.n71 0.00440625
R1200 GND.n111 GND.n73 0.00440625
R1201 GND.n108 GND.n107 0.00440625
R1202 GND.n104 GND.n75 0.00440625
R1203 GND.n103 GND.n77 0.00440625
R1204 GND.n79 GND 0.00440625
R1205 GND.n100 GND.n99 0.00440625
R1206 GND.n96 GND.n80 0.00440625
R1207 GND.n95 GND.n82 0.00440625
R1208 GND.n92 GND.n91 0.00440625
R1209 GND.n88 GND.n84 0.00440625
R1210 GND.n87 GND.n86 0.00440625
R1211 GND.n159 GND.n42 0.00440625
R1212 GND.n156 GND.n155 0.00440625
R1213 GND.n47 GND.n46 0.00440625
R1214 GND.n231 GND.n230 0.00440625
R1215 GND.n227 GND.n5 0.00440625
R1216 GND.n226 GND.n6 0.00440625
R1217 GND.n10 GND.n7 0.00440625
R1218 GND.n222 GND.n221 0.00440625
R1219 GND.n218 GND.n9 0.00440625
R1220 GND.n217 GND.n13 0.00440625
R1221 GND.n214 GND.n213 0.00440625
R1222 GND.n210 GND.n15 0.00440625
R1223 GND.n209 GND.n17 0.00440625
R1224 GND.n206 GND.n205 0.00440625
R1225 GND.n202 GND.n19 0.00440625
R1226 GND.n201 GND.n21 0.00440625
R1227 GND.n198 GND.n197 0.00440625
R1228 GND.n194 GND.n24 0.00440625
R1229 GND.n193 GND.n26 0.00440625
R1230 GND.n190 GND.n189 0.00440625
R1231 GND.n186 GND.n28 0.00440625
R1232 GND.n185 GND.n30 0.00440625
R1233 GND.n32 GND 0.00440625
R1234 GND.n182 GND.n181 0.00440625
R1235 GND.n178 GND.n33 0.00440625
R1236 GND.n177 GND.n35 0.00440625
R1237 GND.n174 GND.n173 0.00440625
R1238 GND.n170 GND.n37 0.00440625
R1239 GND.n169 GND.n39 0.00440625
R1240 GND.n166 GND.n165 0.00440625
R1241 GND.n163 GND.n162 0.00440625
R1242 GND.n236 GND.n0 0.00440625
R1243 GND.n61 GND 0.00180208
R1244 GND.n70 GND 0.00180208
R1245 GND.n160 GND 0.00180208
R1246 GND.n60 GND 0.00180208
R1247 GND.n23 GND 0.00180208
R1248 GND.n161 GND 0.00180208
C0 x1.x5.Y x1.x1.Y 0.106f
C1 VDD x4.Cin 1.01399f
C2 x2.x2.Y VDD 0.776f
C3 VDD x4.x6.Y 0.59757f
C4 VDD A[2] 0.39309f
C5 x1.x4.Y x1.x1.Y 0.13503f
C6 VDD x3.x3.Y 0.37348f
C7 x2.x1.Y x1.x1.Y 0.15532f
C8 x4.x2.Y x4.x1.Y 0.13646f
C9 VDD x2.x6.Y 0.62231f
C10 x2.x1.Y Sum[1] 0.11684f
C11 VDD Sum[2] 0.26923f
C12 x1.x1.Y Sum[0] 0.11678f
C13 A[0] x1.x2.Y 0.17705f
C14 VDD Sum[3] 0.26133f
C15 B[3] x4.x1.Y 0.21916f
C16 VDD A[1] 0.41144f
C17 x4.Cin x4.x2.Y 0.20691f
C18 x1.x5.Y x1.x6.Y 0.33968f
C19 x2.Cin x2.x2.Y 0.20691f
C20 x4.Cin B[3] 0.21642f
C21 x3.x5.Y x3.x4.Y 0.43655f
C22 x3.Cin x3.x5.Y 0.23999f
C23 x1.x4.Y x1.x6.Y 0.1484f
C24 x2.x3.Y x2.x2.Y 0.21875f
C25 x1.x1.Y Cin 0.28698f
C26 x3.x1.Y x4.x1.Y 0.15532f
C27 VDD x1.x2.Y 0.77288f
C28 x3.Cin x3.x1.Y 0.29001f
C29 x3.x1.Y x3.x4.Y 0.13503f
C30 x2.Cin x2.x6.Y 0.10125f
C31 x3.x1.Y B[2] 0.21916f
C32 x1.x6.Y Sum[0] 0.14186f
C33 x4.x7.Y x4.x6.Y 0.10264f
C34 x3.x1.Y x4.Cin 0.1896f
C35 x3.x1.Y A[2] 0.38956f
C36 VDD A[0] 0.38462f
C37 x3.x1.Y x3.x3.Y 0.28946f
C38 x2.x2.Y x2.x4.Y 0.16744f
C39 x1.x6.Y Cin 0.10118f
C40 x2.x1.Y x3.Cin 0.15615f
C41 x3.x4.Y x3.x6.Y 0.1484f
C42 x3.Cin x3.x6.Y 0.1015f
C43 x3.x1.Y Sum[2] 0.11678f
C44 x2.x2.Y x2.x1.Y 0.13646f
C45 x2.x4.Y x2.x6.Y 0.1484f
C46 x2.x7.Y x2.x6.Y 0.10264f
C47 x2.x1.Y x2.x6.Y 0.1045f
C48 x3.x6.Y Sum[2] 0.14186f
C49 x2.x1.Y A[1] 0.38956f
C50 x4.x5.Y x4.x1.Y 0.106f
C51 VDD x4.x2.Y 0.77259f
C52 x2.Cin VDD 1.06593f
C53 x4.Cin x4.x5.Y 0.2401f
C54 B[0] x1.x1.Y 0.21916f
C55 x1.x4.Y x1.x2.Y 0.16744f
C56 x4.x6.Y x4.x5.Y 0.33968f
C57 x2.x3.Y VDD 0.38117f
C58 VDD B[3] 0.25922f
C59 VDD x3.x5.Y 1.01426f
C60 x4.x4.Y x4.x1.Y 0.13503f
C61 VDD x4.x7.Y 0.32832f
C62 VDD x3.x1.Y 0.71037f
C63 x4.Cin x4.x4.Y 0.27412f
C64 x4.x4.Y x4.x6.Y 0.1484f
C65 Cin x1.x2.Y 0.20392f
C66 VDD x2.x4.Y 0.44109f
C67 VDD x1.x5.Y 0.99625f
C68 VDD x2.x7.Y 0.33557f
C69 VDD x1.x4.Y 0.4327f
C70 x1.x3.Y x1.x1.Y 0.28946f
C71 VDD x2.x1.Y 0.71137f
C72 x2.x6.Y x2.x5.Y 0.33968f
C73 VDD x3.x6.Y 0.62563f
C74 x1.x7.Y x1.x6.Y 0.10264f
C75 Cout x4.x1.Y 0.14538f
C76 VDD Sum[0] 0.26926f
C77 A[1] B[1] 0.29709f
C78 x2.Cin x2.x4.Y 0.27412f
C79 x4.x3.Y x4.x1.Y 0.28946f
C80 x3.x1.Y x3.x5.Y 0.106f
C81 x3.x2.Y x3.x4.Y 0.16744f
C82 x3.x2.Y x3.Cin 0.20474f
C83 VDD Cin 0.64622f
C84 x1.x6.Y x1.x1.Y 0.1045f
C85 x2.Cin x2.x1.Y 0.30276f
C86 A[3] x4.x1.Y 0.38956f
C87 x3.x2.Y A[2] 0.17705f
C88 x2.x3.Y x2.x1.Y 0.28946f
C89 VDD x4.x5.Y 0.99172f
C90 x3.x2.Y x3.x3.Y 0.21875f
C91 x3.x5.Y x3.x6.Y 0.33968f
C92 x1.x4.Y x1.x5.Y 0.43655f
C93 x3.x1.Y x3.x6.Y 0.1045f
C94 VDD x4.x4.Y 0.4327f
C95 x2.x4.Y x2.x1.Y 0.13503f
C96 VDD B[1] 0.27309f
C97 VDD x2.x5.Y 1.00976f
C98 B[0] A[0] 0.28871f
C99 x2.x6.Y Sum[1] 0.14186f
C100 x4.x2.Y x4.x4.Y 0.16744f
C101 x1.x5.Y Cin 0.23986f
C102 x4.x7.Y x4.x5.Y 0.2823f
C103 x1.x4.Y Cin 0.27347f
C104 x2.Cin B[1] 0.21642f
C105 x2.Cin x2.x5.Y 0.2401f
C106 VDD Cout 0.31978f
C107 VDD B[0] 0.26006f
C108 x1.x3.Y x1.x2.Y 0.21875f
C109 x1.x1.Y x1.x2.Y 0.13646f
C110 VDD x4.x3.Y 0.37373f
C111 x3.Cin x3.x4.Y 0.27367f
C112 VDD x3.x2.Y 0.77658f
C113 VDD x3.x7.Y 0.33057f
C114 x3.Cin B[2] 0.16218f
C115 x4.Cin x4.x1.Y 0.30276f
C116 x4.x6.Y x4.x1.Y 0.1045f
C117 VDD x1.x7.Y 0.32347f
C118 A[0] x1.x1.Y 0.38956f
C119 VDD A[3] 0.403f
C120 A[2] B[2] 0.28871f
C121 x4.Cin x4.x6.Y 0.10125f
C122 x2.x4.Y x2.x5.Y 0.43655f
C123 x4.x2.Y x4.x3.Y 0.21875f
C124 x3.Cin x2.x6.Y 0.10156f
C125 x2.x7.Y x2.x5.Y 0.2823f
C126 Sum[3] x4.x1.Y 0.11684f
C127 VDD x1.x3.Y 0.36639f
C128 VDD x1.x1.Y 0.69414f
C129 x2.x1.Y B[1] 0.21916f
C130 x2.x1.Y x2.x5.Y 0.106f
C131 VDD Sum[1] 0.26127f
C132 x4.x2.Y A[3] 0.17705f
C133 x4.x6.Y Sum[3] 0.14186f
C134 x2.x2.Y A[1] 0.17705f
C135 x3.x7.Y x3.x5.Y 0.2823f
C136 A[3] B[3] 0.29709f
C137 x3.x2.Y x3.x1.Y 0.13646f
C138 VDD x1.x6.Y 0.59931f
C139 x2.Cin x1.x1.Y 0.1896f
C140 x4.x4.Y x4.x5.Y 0.43655f
C141 x1.x7.Y x1.x5.Y 0.2823f
C142 x3.x7.Y x3.x6.Y 0.10264f
C143 VDD x4.x1.Y 0.69407f
C144 VDD x3.Cin 1.14681f
C145 VDD x3.x4.Y 0.44118f
C146 B[0] Cin 0.16123f
C147 VDD B[2] 0.27394f
C148 Sum[3] GND 0.83672f
C149 Cout GND 0.60651f
C150 A[3] GND 0.33204f
C151 B[3] GND 0.5298f
C152 Sum[2] GND 0.83557f
C153 A[2] GND 0.30548f
C154 B[2] GND 0.51429f
C155 Sum[1] GND 0.83766f
C156 A[1] GND 0.32082f
C157 B[1] GND 0.51922f
C158 Sum[0] GND 0.83482f
C159 Cin GND 1.0732f
C160 A[0] GND 0.31688f
C161 B[0] GND 0.52557f
C162 VDD GND 22.83999f
C163 x4.x3.Y GND 0.36651f
C164 x4.x2.Y GND 0.30568f
C165 x4.x4.Y GND 0.70419f
C166 x4.x7.Y GND 0.47746f
C167 x4.x6.Y GND 0.4516f
C168 x4.x5.Y GND 0.62413f
C169 x4.x1.Y GND 1.54316f
C170 x4.Cin GND 1.18823f
C171 x3.x6.Y GND 0.33876f
C172 x3.x7.Y GND 0.48131f
C173 x3.x5.Y GND 0.60364f
C174 x3.x4.Y GND 0.69332f
C175 x3.x2.Y GND 0.29685f
C176 x3.x3.Y GND 0.37201f
C177 x3.x1.Y GND 1.49267f
C178 x3.Cin GND 0.79017f
C179 x2.x3.Y GND 0.35973f
C180 x2.x2.Y GND 0.2992f
C181 x2.x4.Y GND 0.69117f
C182 x2.x7.Y GND 0.47076f
C183 x2.x6.Y GND 0.35565f
C184 x2.x5.Y GND 0.6048f
C185 x2.x1.Y GND 1.50951f
C186 x2.Cin GND 1.02941f
C187 x1.x6.Y GND 0.43613f
C188 x1.x7.Y GND 0.48807f
C189 x1.x5.Y GND 0.62361f
C190 x1.x4.Y GND 0.70642f
C191 x1.x2.Y GND 0.30337f
C192 x1.x3.Y GND 0.37872f
C193 x1.x1.Y GND 1.52003f
C194 VDD.n75 GND 0.65319f
C195 VDD.t102 GND 0.11132f
C196 VDD.t100 GND 0.11132f
C197 VDD.t68 GND 0.11132f
C198 VDD.t0 GND 0.11132f
C199 VDD.t58 GND 0.11132f
C200 VDD.t60 GND 0.11132f
C201 VDD.t12 GND 0.11132f
C202 VDD.t88 GND 0.11132f
C203 VDD.t66 GND 0.18316f
C204 VDD.n83 GND 0.1765f
C205 VDD.n108 GND 0.65413f
C206 VDD.n164 GND 0.65366f
C207 VDD.t128 GND 0.12969f
C208 VDD.t130 GND 0.12969f
C209 VDD.t48 GND 0.12969f
C210 VDD.t74 GND 0.12969f
C211 VDD.t56 GND 0.12969f
C212 VDD.t54 GND 0.12969f
C213 VDD.t20 GND 0.12969f
C214 VDD.t108 GND 0.12969f
C215 VDD.t50 GND 0.18316f
C216 VDD.n206 GND 0.1765f
C217 VDD.n216 GND 0.65413f
C218 VDD.t126 GND 0.15602f
C219 VDD.t84 GND 0.1315f
C220 VDD.t40 GND 0.1694f
C221 VDD.t18 GND 0.1315f
C222 VDD.t124 GND 0.1694f
C223 VDD.t70 GND 0.1315f
C224 VDD.t38 GND 0.1694f
C225 VDD.t86 GND 0.1315f
C226 VDD.t110 GND 0.1694f
C227 VDD.t72 GND 0.1315f
C228 VDD.t28 GND 0.1694f
C229 VDD.t2 GND 0.1315f
C230 VDD.t112 GND 0.1694f
C231 VDD.t116 GND 0.1315f
C232 VDD.t46 GND 0.1694f
C233 VDD.t8 GND 0.1315f
C234 VDD.t30 GND 0.1694f
C235 VDD.t118 GND 0.1315f
C236 B[0].n0 GND 0.13507f
C237 B[0].n1 GND 0.13567f
C238 B[0].n3 GND 0.34218f
C239 B[0].n4 GND 0.16431f
C240 A[0].n0 GND 0.17912f
C241 A[0].n2 GND 0.40435f
C242 A[0].n3 GND 0.17912f
C243 Cin.n0 GND 0.16908f
C244 Cin.n1 GND 0.16919f
C245 Cin.n3 GND 0.85867f
C246 Cin.n4 GND 0.11091f
C247 Sum[0].n1 GND 0.20064f
C248 B[1].n0 GND 0.14283f
C249 B[1].n2 GND 0.36623f
C250 B[1].n3 GND 0.14283f
C251 B[1].n4 GND 0.165f
C252 A[1].n0 GND 0.18587f
C253 A[1].n1 GND 0.18587f
C254 A[1].n3 GND 0.41619f
C255 Sum[1].n0 GND 0.1318f
C256 B[2].n0 GND 0.13717f
C257 B[2].n1 GND 0.13778f
C258 B[2].n3 GND 0.34749f
C259 B[2].n4 GND 0.16686f
C260 A[2].n0 GND 0.18169f
C261 A[2].n2 GND 0.41016f
C262 A[2].n3 GND 0.18169f
C263 Sum[2].n1 GND 0.20108f
C264 B[3].n0 GND 0.14082f
C265 B[3].n2 GND 0.36108f
C266 B[3].n3 GND 0.14082f
C267 B[3].n4 GND 0.16268f
C268 A[3].n0 GND 0.18355f
C269 A[3].n1 GND 0.18355f
C270 A[3].n3 GND 0.41098f
C271 Cout.n3 GND 0.10535f
C272 Sum[3].n0 GND 0.13144f
.ends
