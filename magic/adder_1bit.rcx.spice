* NGSPICE file created from adder_1bit.ext - technology: sky130A

.subckt adder_1bit A B Cin Cout Sum VDD GND
X0 x6.Y x5.Y VDD.t17 VDD.t16 sky130_fd_pr__pfet_01v8_hvt ad=0.135 pd=1.27 as=0.26 ps=2.52 w=1 l=0.15
X1 VDD.t13 x4.Y x5.Y VDD.t12 sky130_fd_pr__pfet_01v8_hvt ad=0.26 pd=2.52 as=0.135 ps=1.27 w=1 l=0.15
X2 a_1807_95# Cin.t0 GND.t22 GND.t21 sky130_fd_pr__nfet_01v8 ad=0.08775 pd=0.92 as=0.169 ps=1.82 w=0.65 l=0.15
X3 a_427_95# x1.Y GND.t4 GND.t3 sky130_fd_pr__nfet_01v8 ad=0.08775 pd=0.92 as=0.169 ps=1.82 w=0.65 l=0.15
X4 VDD.t5 x1.Y x3.Y VDD.t4 sky130_fd_pr__pfet_01v8_hvt ad=0.26 pd=2.52 as=0.135 ps=1.27 w=1 l=0.15
X5 VDD.t3 x2.Y x4.Y VDD.t2 sky130_fd_pr__pfet_01v8_hvt ad=0.26 pd=2.52 as=0.135 ps=1.27 w=1 l=0.15
X6 a_703_95# B.t0 GND.t16 GND.t15 sky130_fd_pr__nfet_01v8 ad=0.08775 pd=0.92 as=0.169 ps=1.82 w=0.65 l=0.15
X7 x4.Y x3.Y VDD.t1 VDD.t0 sky130_fd_pr__pfet_01v8_hvt ad=0.135 pd=1.27 as=0.26 ps=2.52 w=1 l=0.15
X8 x5.Y Cin.t3 VDD.t27 VDD.t26 sky130_fd_pr__pfet_01v8_hvt ad=0.135 pd=1.27 as=0.26 ps=2.52 w=1 l=0.15
X9 VDD.t33 A.t2 x2.Y VDD.t32 sky130_fd_pr__pfet_01v8_hvt ad=0.26 pd=2.52 as=0.135 ps=1.27 w=1 l=0.15
X10 VDD.t9 x1.Y Cout.t0 VDD.t8 sky130_fd_pr__pfet_01v8_hvt ad=0.26 pd=2.52 as=0.135 ps=1.27 w=1 l=0.15
X11 x3.Y B.t2 VDD.t23 VDD.t22 sky130_fd_pr__pfet_01v8_hvt ad=0.135 pd=1.27 as=0.26 ps=2.52 w=1 l=0.15
X12 x4.Y x2.Y a_979_95# GND.t2 sky130_fd_pr__nfet_01v8 ad=0.169 pd=1.82 as=0.08775 ps=0.92 w=0.65 l=0.15
X13 x2.Y x1.Y VDD.t7 VDD.t6 sky130_fd_pr__pfet_01v8_hvt ad=0.135 pd=1.27 as=0.26 ps=2.52 w=1 l=0.15
X14 VDD.t15 x6.Y Sum.t0 VDD.t14 sky130_fd_pr__pfet_01v8_hvt ad=0.26 pd=2.52 as=0.135 ps=1.27 w=1 l=0.15
X15 Cout.t2 x5.Y VDD.t21 VDD.t20 sky130_fd_pr__pfet_01v8_hvt ad=0.135 pd=1.27 as=0.26 ps=2.52 w=1 l=0.15
X16 x3.Y x1.Y a_703_95# GND.t5 sky130_fd_pr__nfet_01v8 ad=0.169 pd=1.82 as=0.08775 ps=0.92 w=0.65 l=0.15
X17 a_2083_95# x7.Y GND.t24 GND.t23 sky130_fd_pr__nfet_01v8 ad=0.08775 pd=0.92 as=0.169 ps=1.82 w=0.65 l=0.15
X18 Sum.t2 x7.Y VDD.t31 VDD.t30 sky130_fd_pr__pfet_01v8_hvt ad=0.135 pd=1.27 as=0.26 ps=2.52 w=1 l=0.15
X19 a_1255_95# Cin.t1 GND.t20 GND.t19 sky130_fd_pr__nfet_01v8 ad=0.08775 pd=0.92 as=0.169 ps=1.82 w=0.65 l=0.15
X20 a_1531_95# x5.Y GND.t11 GND.t10 sky130_fd_pr__nfet_01v8 ad=0.08775 pd=0.92 as=0.169 ps=1.82 w=0.65 l=0.15
X21 VDD.t35 A.t3 x1.Y VDD.t34 sky130_fd_pr__pfet_01v8_hvt ad=0.26 pd=2.52 as=0.135 ps=1.27 w=1 l=0.15
X22 a_151_95# B.t1 GND.t18 GND.t17 sky130_fd_pr__nfet_01v8 ad=0.08775 pd=0.92 as=0.169 ps=1.82 w=0.65 l=0.15
X23 Sum.t1 x6.Y a_2083_95# GND.t9 sky130_fd_pr__nfet_01v8 ad=0.169 pd=1.82 as=0.08775 ps=0.92 w=0.65 l=0.15
X24 VDD.t19 x5.Y x7.Y VDD.t18 sky130_fd_pr__pfet_01v8_hvt ad=0.26 pd=2.52 as=0.135 ps=1.27 w=1 l=0.15
X25 a_979_95# x3.Y GND.t1 GND.t0 sky130_fd_pr__nfet_01v8 ad=0.08775 pd=0.92 as=0.169 ps=1.82 w=0.65 l=0.15
X26 Cout.t1 x1.Y a_2359_95# GND.t6 sky130_fd_pr__nfet_01v8 ad=0.169 pd=1.82 as=0.08775 ps=0.92 w=0.65 l=0.15
X27 x1.Y B.t3 VDD.t25 VDD.t24 sky130_fd_pr__pfet_01v8_hvt ad=0.135 pd=1.27 as=0.26 ps=2.52 w=1 l=0.15
X28 VDD.t11 x4.Y x6.Y VDD.t10 sky130_fd_pr__pfet_01v8_hvt ad=0.26 pd=2.52 as=0.135 ps=1.27 w=1 l=0.15
X29 x7.Y Cin.t2 VDD.t29 VDD.t28 sky130_fd_pr__pfet_01v8_hvt ad=0.135 pd=1.27 as=0.26 ps=2.52 w=1 l=0.15
X30 x5.Y x4.Y a_1255_95# GND.t7 sky130_fd_pr__nfet_01v8 ad=0.169 pd=1.82 as=0.08775 ps=0.92 w=0.65 l=0.15
X31 x1.Y A.t1 a_151_95# GND.t25 sky130_fd_pr__nfet_01v8 ad=0.169 pd=1.82 as=0.08775 ps=0.92 w=0.65 l=0.15
X32 x6.Y x4.Y a_1531_95# GND.t8 sky130_fd_pr__nfet_01v8 ad=0.169 pd=1.82 as=0.08775 ps=0.92 w=0.65 l=0.15
X33 a_2359_95# x5.Y GND.t14 GND.t13 sky130_fd_pr__nfet_01v8 ad=0.08775 pd=0.92 as=0.169 ps=1.82 w=0.65 l=0.15
X34 x7.Y x5.Y a_1807_95# GND.t12 sky130_fd_pr__nfet_01v8 ad=0.169 pd=1.82 as=0.08775 ps=0.92 w=0.65 l=0.15
X35 x2.Y A.t0 a_427_95# GND.t26 sky130_fd_pr__nfet_01v8 ad=0.169 pd=1.82 as=0.08775 ps=0.92 w=0.65 l=0.15
R0 Cout.n1 Cout.n0 192.982
R1 Cout.n2 Cout.t1 140.53
R2 Cout Cout.n1 44.5962
R3 Cout.n0 Cout.t0 26.5955
R4 Cout.n0 Cout.t2 26.5955
R5 Cout.n1 Cout 20.3004
R6 Cout.n2 Cout 16.5652
R7 Cout Cout.n2 9.03579
R8 Cout.n2 Cout 1.72748
R9 Sum Sum.n0 237.577
R10 Sum.n1 Sum.t1 139.514
R11 Sum.n0 Sum.t0 26.5955
R12 Sum.n0 Sum.t2 26.5955
R13 Sum.n2 Sum 16.5652
R14 Sum.n1 Sum 11.5108
R15 Sum.n2 Sum 9.03579
R16 Sum Sum.n2 1.72748
R17 Sum.n2 Sum.n1 1.01637
R18 Cin.n1 Cin.t3 229.369
R19 Cin.n0 Cin.t2 229.369
R20 Cin.n1 Cin.t1 157.07
R21 Cin.n0 Cin.t0 157.07
R22 Cin.n2 Cin.n1 152.475
R23 Cin.n4 Cin.n0 152
R24 Cin.n4 Cin.n3 16.115
R25 Cin.n3 Cin.n2 13.8025
R26 Cin.n3 Cin 5.99157
R27 Cin Cin.n4 5.92643
R28 Cin.n2 Cin 5.45235
R29 A.n0 A.t3 230.155
R30 A.n3 A.t2 230.155
R31 A.n0 A.t1 157.856
R32 A.n3 A.t0 157.856
R33 A.n1 A.n0 152
R34 A.n4 A.n3 152
R35 A.n4 A.n2 11.0436
R36 A.n2 A.n1 9.82035
R37 A.n1 A 2.10199
R38 A A.n4 2.10199
R39 A.n2 A 1.188
R40 B.n1 B.t3 229.369
R41 B.n0 B.t2 229.369
R42 B.n1 B.t1 157.07
R43 B.n0 B.t0 157.07
R44 B.n2 B.n1 154.845
R45 B.n4 B.n0 152
R46 B.n4 B.n3 20.6978
R47 B.n3 B.n2 9.3005
R48 B B.n4 5.92643
R49 B.n2 B 3.08198
R50 B.n3 B 0.317185
R51 VDD.n54 VDD.t8 627.449
R52 VDD VDD.t14 361.06
R53 VDD VDD.t18 361.06
R54 VDD VDD.t10 361.06
R55 VDD VDD.t12 361.06
R56 VDD VDD.t2 361.06
R57 VDD VDD.t4 361.06
R58 VDD VDD.t32 361.06
R59 VDD VDD.t34 361.06
R60 VDD.n13 VDD.t35 249.363
R61 VDD.n18 VDD.t33 249.363
R62 VDD.n23 VDD.t5 249.363
R63 VDD.n28 VDD.t3 249.363
R64 VDD.n33 VDD.t13 249.363
R65 VDD.n38 VDD.t11 249.363
R66 VDD.n43 VDD.t19 249.363
R67 VDD.n48 VDD.t15 249.363
R68 VDD.n53 VDD.t9 249.363
R69 VDD.t8 VDD.t20 248.599
R70 VDD.t14 VDD.t30 248.599
R71 VDD.t18 VDD.t28 248.599
R72 VDD.t10 VDD.t16 248.599
R73 VDD.t12 VDD.t26 248.599
R74 VDD.t2 VDD.t0 248.599
R75 VDD.t4 VDD.t22 248.599
R76 VDD.t32 VDD.t6 248.599
R77 VDD.t34 VDD.t24 248.599
R78 VDD.n14 VDD.t7 247.394
R79 VDD.n19 VDD.t23 247.394
R80 VDD.n24 VDD.t1 247.394
R81 VDD.n29 VDD.t27 247.394
R82 VDD.n34 VDD.t17 247.394
R83 VDD.n39 VDD.t29 247.394
R84 VDD.n44 VDD.t31 247.394
R85 VDD.n49 VDD.t21 247.394
R86 VDD.n9 VDD.t25 247.393
R87 VDD.t20 VDD 207.166
R88 VDD.t30 VDD 207.166
R89 VDD.t28 VDD 207.166
R90 VDD.t16 VDD 207.166
R91 VDD.t26 VDD 207.166
R92 VDD.t0 VDD 207.166
R93 VDD.t22 VDD 207.166
R94 VDD.t6 VDD 207.166
R95 VDD.t24 VDD 207.166
R96 VDD.n13 VDD.n8 25.977
R97 VDD.n18 VDD.n7 25.977
R98 VDD.n23 VDD.n6 25.977
R99 VDD.n28 VDD.n5 25.977
R100 VDD.n33 VDD.n4 25.977
R101 VDD.n38 VDD.n3 25.977
R102 VDD.n43 VDD.n2 25.977
R103 VDD.n48 VDD.n1 25.977
R104 VDD.n53 VDD.n0 25.977
R105 VDD.n9 VDD.n8 24.4711
R106 VDD.n14 VDD.n7 24.4711
R107 VDD.n19 VDD.n6 24.4711
R108 VDD.n24 VDD.n5 24.4711
R109 VDD.n29 VDD.n4 24.4711
R110 VDD.n34 VDD.n3 24.4711
R111 VDD.n39 VDD.n2 24.4711
R112 VDD.n44 VDD.n1 24.4711
R113 VDD.n49 VDD.n0 24.4711
R114 VDD.n14 VDD.n13 12.8005
R115 VDD.n19 VDD.n18 12.8005
R116 VDD.n24 VDD.n23 12.8005
R117 VDD.n29 VDD.n28 12.8005
R118 VDD.n34 VDD.n33 12.8005
R119 VDD.n39 VDD.n38 12.8005
R120 VDD.n44 VDD.n43 12.8005
R121 VDD.n49 VDD.n48 12.8005
R122 VDD.n54 VDD.n53 12.8005
R123 VDD.n55 VDD.n54 9.3005
R124 VDD.n53 VDD.n52 9.3005
R125 VDD.n51 VDD.n0 9.3005
R126 VDD.n50 VDD.n49 9.3005
R127 VDD.n48 VDD.n47 9.3005
R128 VDD.n46 VDD.n1 9.3005
R129 VDD.n45 VDD.n44 9.3005
R130 VDD.n43 VDD.n42 9.3005
R131 VDD.n41 VDD.n2 9.3005
R132 VDD.n40 VDD.n39 9.3005
R133 VDD.n38 VDD.n37 9.3005
R134 VDD.n36 VDD.n3 9.3005
R135 VDD.n35 VDD.n34 9.3005
R136 VDD.n33 VDD.n32 9.3005
R137 VDD.n31 VDD.n4 9.3005
R138 VDD.n30 VDD.n29 9.3005
R139 VDD.n28 VDD.n27 9.3005
R140 VDD.n26 VDD.n5 9.3005
R141 VDD.n25 VDD.n24 9.3005
R142 VDD.n23 VDD.n22 9.3005
R143 VDD.n21 VDD.n6 9.3005
R144 VDD.n20 VDD.n19 9.3005
R145 VDD.n18 VDD.n17 9.3005
R146 VDD.n16 VDD.n7 9.3005
R147 VDD.n15 VDD.n14 9.3005
R148 VDD.n13 VDD.n12 9.3005
R149 VDD.n11 VDD.n8 9.3005
R150 VDD.n10 VDD.n9 9.3005
R151 VDD.n52 VDD.n51 0.120292
R152 VDD.n51 VDD.n50 0.120292
R153 VDD.n47 VDD.n46 0.120292
R154 VDD.n46 VDD.n45 0.120292
R155 VDD.n42 VDD.n41 0.120292
R156 VDD.n41 VDD.n40 0.120292
R157 VDD.n37 VDD.n36 0.120292
R158 VDD.n36 VDD.n35 0.120292
R159 VDD.n32 VDD.n31 0.120292
R160 VDD.n31 VDD.n30 0.120292
R161 VDD.n27 VDD.n26 0.120292
R162 VDD.n26 VDD.n25 0.120292
R163 VDD.n22 VDD.n21 0.120292
R164 VDD.n21 VDD.n20 0.120292
R165 VDD.n17 VDD.n16 0.120292
R166 VDD.n16 VDD.n15 0.120292
R167 VDD.n12 VDD.n11 0.120292
R168 VDD.n11 VDD.n10 0.120292
R169 VDD VDD.n55 0.0603958
R170 VDD.n52 VDD 0.0603958
R171 VDD.n47 VDD 0.0603958
R172 VDD.n42 VDD 0.0603958
R173 VDD.n37 VDD 0.0603958
R174 VDD.n32 VDD 0.0603958
R175 VDD.n27 VDD 0.0603958
R176 VDD.n22 VDD 0.0603958
R177 VDD.n17 VDD 0.0603958
R178 VDD.n12 VDD 0.0603958
R179 VDD.n55 VDD 0.03175
R180 VDD.n50 VDD 0.0239375
R181 VDD.n45 VDD 0.0239375
R182 VDD.n40 VDD 0.0239375
R183 VDD.n35 VDD 0.0239375
R184 VDD.n30 VDD 0.0239375
R185 VDD.n25 VDD 0.0239375
R186 VDD.n20 VDD 0.0239375
R187 VDD.n15 VDD 0.0239375
R188 VDD.n10 VDD 0.0239375
R189 GND.n54 GND.t6 3191.78
R190 GND GND.t9 1737.22
R191 GND GND.t12 1737.22
R192 GND GND.t8 1737.22
R193 GND GND.t7 1737.22
R194 GND GND.t2 1737.22
R195 GND GND.t5 1737.22
R196 GND GND.t26 1737.22
R197 GND GND.t25 1737.22
R198 GND.t6 GND.t13 1196.12
R199 GND.t9 GND.t23 1196.12
R200 GND.t12 GND.t21 1196.12
R201 GND.t8 GND.t10 1196.12
R202 GND.t7 GND.t19 1196.12
R203 GND.t2 GND.t0 1196.12
R204 GND.t5 GND.t15 1196.12
R205 GND.t26 GND.t3 1196.12
R206 GND.t25 GND.t17 1196.12
R207 GND.t13 GND 996.764
R208 GND.t23 GND 996.764
R209 GND.t21 GND 996.764
R210 GND.t10 GND 996.764
R211 GND.t19 GND 996.764
R212 GND.t0 GND 996.764
R213 GND.t15 GND 996.764
R214 GND.t3 GND 996.764
R215 GND.t17 GND 996.764
R216 GND.n49 GND.t14 150.922
R217 GND.n44 GND.t24 150.922
R218 GND.n39 GND.t22 150.922
R219 GND.n34 GND.t11 150.922
R220 GND.n29 GND.t20 150.922
R221 GND.n24 GND.t1 150.922
R222 GND.n19 GND.t16 150.922
R223 GND.n14 GND.t4 150.922
R224 GND.n9 GND.t18 150.922
R225 GND.n53 GND.n0 34.6358
R226 GND.n48 GND.n1 34.6358
R227 GND.n43 GND.n2 34.6358
R228 GND.n38 GND.n3 34.6358
R229 GND.n33 GND.n4 34.6358
R230 GND.n28 GND.n5 34.6358
R231 GND.n23 GND.n6 34.6358
R232 GND.n18 GND.n7 34.6358
R233 GND.n13 GND.n8 34.6358
R234 GND.n54 GND.n53 23.7181
R235 GND.n49 GND.n48 23.7181
R236 GND.n44 GND.n43 23.7181
R237 GND.n39 GND.n38 23.7181
R238 GND.n34 GND.n33 23.7181
R239 GND.n29 GND.n28 23.7181
R240 GND.n24 GND.n23 23.7181
R241 GND.n19 GND.n18 23.7181
R242 GND.n14 GND.n13 23.7181
R243 GND.n49 GND.n0 22.2123
R244 GND.n44 GND.n1 22.2123
R245 GND.n39 GND.n2 22.2123
R246 GND.n34 GND.n3 22.2123
R247 GND.n29 GND.n4 22.2123
R248 GND.n24 GND.n5 22.2123
R249 GND.n19 GND.n6 22.2123
R250 GND.n14 GND.n7 22.2123
R251 GND.n9 GND.n8 22.2123
R252 GND.n10 GND.n9 9.3005
R253 GND.n55 GND.n54 9.3005
R254 GND.n53 GND.n52 9.3005
R255 GND.n51 GND.n0 9.3005
R256 GND.n50 GND.n49 9.3005
R257 GND.n48 GND.n47 9.3005
R258 GND.n46 GND.n1 9.3005
R259 GND.n45 GND.n44 9.3005
R260 GND.n43 GND.n42 9.3005
R261 GND.n41 GND.n2 9.3005
R262 GND.n40 GND.n39 9.3005
R263 GND.n38 GND.n37 9.3005
R264 GND.n36 GND.n3 9.3005
R265 GND.n35 GND.n34 9.3005
R266 GND.n33 GND.n32 9.3005
R267 GND.n31 GND.n4 9.3005
R268 GND.n30 GND.n29 9.3005
R269 GND.n28 GND.n27 9.3005
R270 GND.n26 GND.n5 9.3005
R271 GND.n25 GND.n24 9.3005
R272 GND.n23 GND.n22 9.3005
R273 GND.n21 GND.n6 9.3005
R274 GND.n20 GND.n19 9.3005
R275 GND.n18 GND.n17 9.3005
R276 GND.n16 GND.n7 9.3005
R277 GND.n15 GND.n14 9.3005
R278 GND.n13 GND.n12 9.3005
R279 GND.n11 GND.n8 9.3005
R280 GND.n52 GND.n51 0.120292
R281 GND.n51 GND.n50 0.120292
R282 GND.n47 GND.n46 0.120292
R283 GND.n46 GND.n45 0.120292
R284 GND.n42 GND.n41 0.120292
R285 GND.n41 GND.n40 0.120292
R286 GND.n37 GND.n36 0.120292
R287 GND.n36 GND.n35 0.120292
R288 GND.n32 GND.n31 0.120292
R289 GND.n31 GND.n30 0.120292
R290 GND.n27 GND.n26 0.120292
R291 GND.n26 GND.n25 0.120292
R292 GND.n22 GND.n21 0.120292
R293 GND.n21 GND.n20 0.120292
R294 GND.n17 GND.n16 0.120292
R295 GND.n16 GND.n15 0.120292
R296 GND.n12 GND.n11 0.120292
R297 GND.n11 GND.n10 0.120292
R298 GND GND.n55 0.0603958
R299 GND.n52 GND 0.0603958
R300 GND.n47 GND 0.0603958
R301 GND.n42 GND 0.0603958
R302 GND.n37 GND 0.0603958
R303 GND.n32 GND 0.0603958
R304 GND.n27 GND 0.0603958
R305 GND.n22 GND 0.0603958
R306 GND.n17 GND 0.0603958
R307 GND.n12 GND 0.0603958
R308 GND.n55 GND 0.0330521
R309 GND.n50 GND 0.0239375
R310 GND.n45 GND 0.0239375
R311 GND.n40 GND 0.0239375
R312 GND.n35 GND 0.0239375
R313 GND.n30 GND 0.0239375
R314 GND.n25 GND 0.0239375
R315 GND.n20 GND 0.0239375
R316 GND.n15 GND 0.0239375
R317 GND.n10 GND 0.0239375
C0 x2.Y A 0.17705f
C1 Cin x1.Y 0.28698f
C2 x1.Y A 0.38956f
C3 VDD B 0.20529f
C4 x1.Y Cout 0.14538f
C5 x6.Y VDD 0.48146f
C6 VDD x2.Y 0.7396f
C7 x5.Y x4.Y 0.43655f
C8 x1.Y VDD 0.52413f
C9 VDD x3.Y 0.3495f
C10 x6.Y x4.Y 0.1484f
C11 x2.Y x4.Y 0.16744f
C12 x7.Y VDD 0.3071f
C13 x6.Y x5.Y 0.33968f
C14 x1.Y x4.Y 0.13503f
C15 Sum VDD 0.24764f
C16 x1.Y x5.Y 0.106f
C17 Cin VDD 0.44532f
C18 VDD A 0.37213f
C19 x1.Y B 0.21916f
C20 VDD Cout 0.31874f
C21 x6.Y x1.Y 0.1045f
C22 x7.Y x5.Y 0.2823f
C23 x1.Y x2.Y 0.13646f
C24 x2.Y x3.Y 0.21875f
C25 Cin x4.Y 0.27347f
C26 x1.Y x3.Y 0.28946f
C27 Cin x5.Y 0.23986f
C28 x6.Y x7.Y 0.10264f
C29 x6.Y Sum 0.14186f
C30 VDD x4.Y 0.39829f
C31 Cin B 0.16123f
C32 A B 0.28871f
C33 Sum x1.Y 0.11684f
C34 VDD x5.Y 0.9362f
C35 x6.Y Cin 0.10118f
C36 Cin x2.Y 0.20392f
C37 Cout GND 0.46774f
C38 Sum GND 0.79228f
C39 Cin GND 0.93201f
C40 A GND 0.29753f
C41 B GND 0.53147f
C42 VDD GND 4.69922f
C43 x6.Y GND 0.3983f
C44 x7.Y GND 0.46353f
C45 x5.Y GND 0.57787f
C46 x4.Y GND 0.68394f
C47 x2.Y GND 0.286f
C48 x3.Y GND 0.35113f
C49 x1.Y GND 1.55273f
C50 VDD.t34 GND 0.10869f
C51 VDD.t32 GND 0.10869f
C52 VDD.t4 GND 0.10869f
C53 VDD.t2 GND 0.10869f
C54 VDD.t12 GND 0.10869f
C55 VDD.t10 GND 0.10869f
C56 VDD.t18 GND 0.10869f
C57 VDD.t14 GND 0.10869f
C58 VDD.t8 GND 0.17883f
C59 VDD.n54 GND 0.17233f
C60 B.n0 GND 0.12032f
C61 B.n1 GND 0.12085f
C62 B.n3 GND 0.3048f
C63 B.n4 GND 0.14636f
C64 A.n0 GND 0.17595f
C65 A.n2 GND 0.3972f
C66 A.n3 GND 0.17595f
C67 Cin.n0 GND 0.15134f
C68 Cin.n1 GND 0.15143f
C69 Cin.n3 GND 0.76856f
C70 Sum.n1 GND 0.19016f
C71 Cout.n1 GND 0.11115f
C72 Cout.n2 GND 0.17202f
.ends
