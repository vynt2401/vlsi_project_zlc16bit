.include /usr/local/share/pdk/sky130A/libs.ref/sky130_fd_sc_hd/spice/sky130_fd_sc_hd.spice
.include /home/me/Project/sky130_adder_4bit/xschem/adder_4bit.spice
