** sch_path: /home/me/sky130_adder_4bit/xschem/zlc_4bit.sch
.subckt zlc_4bit Z[2] Z[1] Z[0] A[3] A[2] A[1] A[0] VDD GND
*.PININFO A[3:0]:I Z[2:0]:O VDD:I GND:I
x1 A[3] A[2] A[1] A[0] GND GND VDD VDD Z[2] sky130_fd_sc_hd__nor4_1
x2 A[3] A[2] GND GND VDD VDD net5 sky130_fd_sc_hd__nor2_1
x3 A[1] A[0] GND GND VDD VDD net6 sky130_fd_sc_hd__or2_1
x4 net5 net6 GND GND VDD VDD Z[1] sky130_fd_sc_hd__and2_1
x5 A[3] GND GND VDD VDD net4 sky130_fd_sc_hd__inv_1
x7 net1 A[0] GND GND VDD VDD net2 sky130_fd_sc_hd__and2_1
x8 net2 A[2] GND GND VDD VDD net3 sky130_fd_sc_hd__or2_1
x9 net4 net3 GND GND VDD VDD Z[0] sky130_fd_sc_hd__and2_1
x6 A[1] GND GND VDD VDD net1 sky130_fd_sc_hd__inv_1
.ends
