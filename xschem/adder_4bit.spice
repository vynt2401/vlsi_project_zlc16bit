** sch_path: /home/me/Project/sky130_adder_4bit/xschem/adder_4bit.sch
.subckt adder_4bit A[3] A[2] A[1] A[0] Sum[3] Sum[2] Sum[1] Sum[0] B[3] B[2] B[1] B[0] Cout Cin VDD GND
*.PININFO A[3:0]:I B[3:0]:I Cin:I Sum[3:0]:O Cout:O VDD:I GND:I
x1 A[0] B[0] Sum[0] Cin VDD n1 GND adder_1bit
x2 A[1] B[1] Sum[1] n1 VDD n2 GND adder_1bit
x3 A[2] B[2] Sum[2] n2 VDD n3 GND adder_1bit
x4 A[3] B[3] Sum[3] n3 VDD Cout GND adder_1bit
.ends

* expanding   symbol:  adder_1bit.sym # of pins=7
** sym_path: /home/me/Project/sky130_adder_4bit/xschem/adder_1bit.sym
** sch_path: /home/me/Project/sky130_adder_4bit/xschem/adder_1bit.sch
.subckt adder_1bit A B Sum Cin VDD Cout GND
*.PININFO A:I B:I Cin:I Sum:O Cout:O VDD:I GND:I
x1 A B GND GND VDD VDD T1 sky130_fd_sc_hd__nand2_1
x2 A T1 GND GND VDD VDD net1 sky130_fd_sc_hd__nand2_1
x3 T1 B GND GND VDD VDD net2 sky130_fd_sc_hd__nand2_1
x4 net1 net2 GND GND VDD VDD net5 sky130_fd_sc_hd__nand2_1
x5 net5 Cin GND GND VDD VDD T2 sky130_fd_sc_hd__nand2_1
x6 net5 T2 GND GND VDD VDD net3 sky130_fd_sc_hd__nand2_1
x7 T2 Cin GND GND VDD VDD net4 sky130_fd_sc_hd__nand2_1
x8 net3 net4 GND GND VDD VDD Sum sky130_fd_sc_hd__nand2_1
x9 T1 T2 GND GND VDD VDD Cout sky130_fd_sc_hd__nand2_1
.ends
